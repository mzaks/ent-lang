// A multilevel HfO2 RRAM device of a 1T-1R cell: the enhanced Stanford-PKU
// model of B. Al Beattie, E. Pérez-Bosch Quesada, M. Uhlmann, E. Perez,
// G. Kahmen, E. Solan and K. Ochs, "Wave digital emulation of an enhanced
// compact model for RRAM devices with multilevel capability", IEEE
// Transactions on Nanotechnology 22, 2023 (TechRxiv
// 10.36227/techrxiv.21679964, CC BY 4.0), with its Table I: IHP's
// TiN/Al:HfO2/Ti/TiN stack on 130 nm CMOS. The single source of this model
// for examples/analog. ngspice runs it compiled by OpenVAF; devices.ent
// has it by hand, with the parameters in this order (prepare.py reads the
// order from here), w0 last.
//
// The state z is the filament's gap over its largest, gmax:
//
//   i     = I0 * exp(-z * gmax / g0) * sinh(u / U0)
//   dz/dt = -v0(u) / gmax * exp(-Ea / (kB T)) *
//           sinh(gamma(z, u) * da / dox * q / (kB T) * (u - sgn(u) * uth))
//   T     = T0 + Rth * u * i
//   gamma = gamma0(z, u) * step(gamma0(z, u) * |u| / dox - Emin)
//   gamma0(z, u) = (gamma0 where u >= 0, else gammar) - beta * (z / (gbar / gmax))^alpha
//   v0(u) = v0 where u >= 0, else v0 / zeta^((ug - ug0) / Uhat)
//
// and z stays in [zmin, 1], zmin = ((W/L) / (Eth * ug) + dth) / gmax: the
// gate voltage ug of the cell's transistor in the set sets the low
// resistance (the multilevel states; the transistor itself is not
// modelled, as in the paper). The paper's Eth is printed "25 over 13 V/m"
// and read here as 25/13 with gmin in nm. Swept as its Fig. 6 (0, 1.5,
// -1.5, 0 V from z = 1; circuits/rram_ug*.cir), this sets at 0.63 V and
// gives its model's curves at ug 1 and 1.2 V (the current at 1.5 V, the
// reset's peak, where and how high); at 1.6 V the figure's low resistance
// is that of 1 V, which no gmin falling with ug gives; here it is 2.2 times
// lower than the figure's. Its "e = 1 eV" is the elementary charge (Ea in eV), and
// Rth in K/W.
//
// Lengths are in nm here (Emin in V/nm, v0 in nm/s). Four departures,
// so that an implicit step can hold it. The step in gamma is a logistic
// over `ewidth` of the field (0.01 V/nm, 0.7% of Emin): in the reset the
// state rides that threshold up as the voltage grows, and on a true step
// it chatters (ngspice stops, "timestep too small"). The rate is capped smoothly at
// `rmax` (rate / (1 + |rate| / rmax); the paper's goes past 1e40 a second
// in the low-resistance state at 1 V, where no Newton step settles; 1e8
// crosses the whole gap in 10 ns, about as fast as such a cell switches,
// and is instant for any sweep), and where the paper
// holds z to its interval, this model has a window that brings the
// state to rest at either end over `delta` of it: dz/dt is multiplied by
// 1 - exp(-(z - zmin) / delta) when it falls, 1 - exp(-(1 - z) / delta)
// when it rises, and past an end by the straight line that continues it,
// which turns it back (a hard stop leaves Newton no root to find); and
// the rate's gap, in gamma, is taken within [zmin, 1] (past 1.2 gamma is
// below 0 and its step closes, so the rate is 0 and the window, which
// multiplies it, could not turn back a state that a step threw there). The state is
// the voltage of the internal node `x`, held at w0 in the operating point.

`include "constants.vams"
`include "disciplines.vams"

module rram(a, b);
  inout a, b;
  electrical a, b, x;

  parameter real i0 = 1e-3 from (0:inf);
  parameter real u0 = 0.45 from (0:inf);
  parameter real g0 = 0.285 from (0:inf);
  parameter real gmax = 1.8 from (0:inf);
  parameter real v0 = 1e7 from (0:inf);
  parameter real ea = 0.6 from (0:inf);
  parameter real da = 0.25 from (0:inf);
  parameter real dox = 6 from (0:inf);
  parameter real t0 = 298 from (0:inf);
  parameter real rth = 1500 from [0:inf);
  parameter real gamma0 = 40;
  parameter real gammar = 26;
  parameter real beta = 4.25;
  parameter real alpha = 2.9;
  parameter real gbar = 1 from (0:inf);
  parameter real uth = 0.31 from [0:inf);
  parameter real emin = 1.4 from [0:inf);
  parameter real ewidth = 0.01 from (0:inf);
  parameter real ug = 1 from (0:inf);
  parameter real ug0 = 1;
  parameter real uhat = 0.2 from (0:inf);
  parameter real zeta = 70 from (0:inf);
  parameter real wl = 1.1538461538461537 from (0:inf);
  parameter real eth = 1.9230769230769231 from (0:inf);
  parameter real dth = 0.35 from [0:inf);
  parameter real rmax = 1e8 from (0:inf);
  parameter real delta = 1e-3 from (0:inf);
  parameter real w0 = 1;

  real z, u, i, temp, speed, gam, raw, zmin, zc, window, kq;

  analog begin
    z = V(x);
    u = V(a, b);
    i = i0 * exp(-z * gmax / g0) * sinh(u / u0);
    I(a, b) <+ i;
    temp = t0 + rth * u * i;
    // (q / kB: the elementary charge over Boltzmann's constant, the paper's
    // 1.38e-23 J/K.)
    kq = 1.602176634e-19 / 1.38e-23;
    zmin = (wl / (eth * ug) + dth) / gmax;
    // (The rate's gap taken within [zmin, 1]: past 1.2 gamma0 is below 0,
    // its step closes, and a state thrown there would never come back.)
    zc = min(max(z, zmin), 1);
    if (u >= 0) begin
      speed = v0;
      gam = gamma0 - beta * pow(zc * gmax / gbar, alpha);
    end else begin
      speed = v0 / pow(zeta, (ug - ug0) / uhat);
      gam = gammar - beta * pow(zc * gmax / gbar, alpha);
    end
    gam = gam / (1 + exp(min(-(gam * abs(u) / dox - emin) / ewidth, 700)));
    raw = -speed / gmax * exp(-ea * kq / temp) *
          sinh(gam * da / dox * kq / temp * (u - (u > 0 ? uth : (u < 0 ? -uth : 0))));
    raw = raw / (1 + abs(raw) / rmax);
    if (raw < 0)
      window = z >= zmin ? 1 - exp(-(z - zmin) / delta) : (z - zmin) / delta;
    else
      window = z <= 1 ? 1 - exp(-(1 - z) / delta) : (1 - z) / delta;
    if ($abstime <= 0)
      V(x) <+ w0;
    else
      I(x) <+ ddt(V(x)) - raw * window;
  end
endmodule

Guided axon growth and pruning, the biologically inspired example of Jenderny, Ochs, Xue 2024 (15 by 15): 5 s
Cn1_1 n1_1 0 2n
Xn1_1 n1_1 0 ml w0=9.396401299266444e-07
Cn1_2 n1_2 0 2n
Xn1_2 n1_2 0 ml w0=9.396401299266444e-07
Cn1_3 n1_3 0 2n
Xn1_3 n1_3 0 ml w0=9.396401299266444e-07
Cn1_4 n1_4 0 2n
Xn1_4 n1_4 0 ml w0=9.396401299266444e-07
Cn1_5 n1_5 0 2n
Xn1_5 n1_5 0 ml w0=9.396401299266444e-07
Cn1_6 n1_6 0 2n
Xn1_6 n1_6 0 ml w0=9.396401299266444e-07
Cn1_7 n1_7 0 2n
Xn1_7 n1_7 0 ml w0=9.396401299266444e-07
Cn1_8 n1_8 0 2n
Xn1_8 n1_8 0 ml w0=9.396401299266444e-07
Cn1_9 n1_9 0 2n
Xn1_9 n1_9 0 ml w0=9.396401299266444e-07
Cn1_10 n1_10 0 2n
Xn1_10 n1_10 0 ml w0=9.396401299266444e-07
Cn1_11 n1_11 0 2n
Xn1_11 n1_11 0 ml w0=9.396401299266444e-07
Cn1_12 n1_12 0 2n
Xn1_12 n1_12 0 ml w0=9.396401299266444e-07
Cn1_13 n1_13 0 2n
Xn1_13 n1_13 0 ml w0=9.396401299266444e-07
Cn1_14 n1_14 0 2n
Xn1_14 n1_14 0 ml w0=9.396401299266444e-07
Cn1_15 n1_15 0 2n
Xn1_15 n1_15 0 ml w0=9.396401299266444e-07
Cn2_1 n2_1 0 2n
Xn2_1 n2_1 0 ml w0=9.396401299266444e-07
Cn2_2 n2_2 0 2n
Xn2_2 n2_2 0 ml w0=9.396401299266444e-07
Cn2_3 n2_3 0 2n
Xn2_3 n2_3 0 ml w0=9.396401299266444e-07
Cn2_4 n2_4 0 2n
Xn2_4 n2_4 0 ml w0=9.396401299266444e-07
Cn2_5 n2_5 0 2n
Xn2_5 n2_5 0 ml w0=9.396401299266444e-07
Cn2_6 n2_6 0 2n
Xn2_6 n2_6 0 ml w0=9.396401299266444e-07
Cn2_7 n2_7 0 2n
Xn2_7 n2_7 0 ml w0=9.396401299266444e-07
Cn2_8 n2_8 0 2n
Xn2_8 n2_8 0 ml w0=9.396401299266444e-07
Cn2_9 n2_9 0 2n
Xn2_9 n2_9 0 ml w0=9.396401299266444e-07
Cn2_10 n2_10 0 2n
Xn2_10 n2_10 0 ml w0=9.396401299266444e-07
Cn2_11 n2_11 0 2n
Xn2_11 n2_11 0 ml w0=9.396401299266444e-07
Cn2_12 n2_12 0 2n
Xn2_12 n2_12 0 ml w0=9.396401299266444e-07
Cn2_13 n2_13 0 2n
Xn2_13 n2_13 0 ml w0=9.396401299266444e-07
Cn2_14 n2_14 0 2n
Xn2_14 n2_14 0 ml w0=9.396401299266444e-07
Cn2_15 n2_15 0 2n
Xn2_15 n2_15 0 ml w0=9.396401299266444e-07
Cn3_1 n3_1 0 2n
Xn3_1 n3_1 0 ml w0=9.396401299266444e-07
Cn3_2 n3_2 0 2n
Xn3_2 n3_2 0 ml w0=9.396401299266444e-07
Cn3_3 n3_3 0 2n
Xn3_3 n3_3 0 ml w0=9.396401299266444e-07
Cn3_4 n3_4 0 2n
Xn3_4 n3_4 0 ml w0=9.396401299266444e-07
Cn3_5 n3_5 0 2n
Xn3_5 n3_5 0 ml w0=9.396401299266444e-07
Cn3_6 n3_6 0 2n
Xn3_6 n3_6 0 ml w0=9.396401299266444e-07
Cn3_7 n3_7 0 2n
Xn3_7 n3_7 0 ml w0=9.396401299266444e-07
Cn3_8 n3_8 0 2n
Xn3_8 n3_8 0 ml w0=9.396401299266444e-07
Cn3_9 n3_9 0 2n
Xn3_9 n3_9 0 ml w0=9.396401299266444e-07
Cn3_10 n3_10 0 2n
Xn3_10 n3_10 0 ml w0=9.396401299266444e-07
Cn3_11 n3_11 0 2n
Xn3_11 n3_11 0 ml w0=9.396401299266444e-07
Cn3_12 n3_12 0 2n
Xn3_12 n3_12 0 ml w0=9.396401299266444e-07
Cn3_13 n3_13 0 2n
Xn3_13 n3_13 0 ml w0=9.396401299266444e-07
Cn3_14 n3_14 0 2n
Xn3_14 n3_14 0 ml w0=9.396401299266444e-07
Cn3_15 n3_15 0 2n
Xn3_15 n3_15 0 ml w0=9.396401299266444e-07
Cn4_1 n4_1 0 2n
Xn4_1 n4_1 0 ml w0=9.396401299266444e-07
Cn4_2 n4_2 0 2n
Xn4_2 n4_2 0 ml w0=9.396401299266444e-07
Cn4_3 n4_3 0 2n
Xn4_3 n4_3 0 ml w0=9.396401299266444e-07
Cn4_4 n4_4 0 2n
Xn4_4 n4_4 0 ml w0=9.396401299266444e-07
Cn4_5 n4_5 0 2n
Xn4_5 n4_5 0 ml w0=9.396401299266444e-07
Cn4_6 n4_6 0 2n
Xn4_6 n4_6 0 ml w0=9.396401299266444e-07
Cn4_7 n4_7 0 2n
Xn4_7 n4_7 0 ml w0=9.396401299266444e-07
Cn4_8 n4_8 0 2n
Xn4_8 n4_8 0 ml w0=9.396401299266444e-07
Cn4_9 n4_9 0 2n
Xn4_9 n4_9 0 ml w0=9.396401299266444e-07
Cn4_10 n4_10 0 2n
Xn4_10 n4_10 0 ml w0=9.396401299266444e-07
Cn4_11 n4_11 0 2n
Xn4_11 n4_11 0 ml w0=9.396401299266444e-07
Cn4_12 n4_12 0 2n
Xn4_12 n4_12 0 ml w0=9.396401299266444e-07
Cn4_13 n4_13 0 2n
Xn4_13 n4_13 0 ml w0=9.396401299266444e-07
Cn4_14 n4_14 0 2n
Xn4_14 n4_14 0 ml w0=9.396401299266444e-07
Cn4_15 n4_15 0 2n
Xn4_15 n4_15 0 ml w0=9.396401299266444e-07
Cn5_1 n5_1 0 2n
Xn5_1 n5_1 0 ml w0=9.396401299266444e-07
Cn5_2 n5_2 0 2n
Xn5_2 n5_2 0 ml w0=9.396401299266444e-07
Cn5_3 n5_3 0 2n
Xn5_3 n5_3 0 ml w0=9.396401299266444e-07
Cn5_4 n5_4 0 2n
Xn5_4 n5_4 0 ml w0=9.396401299266444e-07
Cn5_5 n5_5 0 2n
Xn5_5 n5_5 0 ml w0=9.396401299266444e-07
Cn5_6 n5_6 0 2n
Xn5_6 n5_6 0 ml w0=9.396401299266444e-07
Cn5_7 n5_7 0 2n
Xn5_7 n5_7 0 ml w0=9.396401299266444e-07
Cn5_8 n5_8 0 2n
Xn5_8 n5_8 0 ml w0=9.396401299266444e-07
Cn5_9 n5_9 0 2n
Xn5_9 n5_9 0 ml w0=9.396401299266444e-07
Cn5_10 n5_10 0 2n
Xn5_10 n5_10 0 ml w0=9.396401299266444e-07
Cn5_11 n5_11 0 2n
Xn5_11 n5_11 0 ml w0=9.396401299266444e-07
Cn5_12 n5_12 0 2n
Xn5_12 n5_12 0 ml w0=9.396401299266444e-07
Cn5_13 n5_13 0 2n
Xn5_13 n5_13 0 ml w0=9.396401299266444e-07
Cn5_14 n5_14 0 2n
Xn5_14 n5_14 0 ml w0=9.396401299266444e-07
Cn5_15 n5_15 0 2n
Xn5_15 n5_15 0 ml w0=9.396401299266444e-07
Cn6_1 n6_1 0 2n
Xn6_1 n6_1 0 ml w0=9.396401299266444e-07
Cn6_2 n6_2 0 2n
Xn6_2 n6_2 0 ml w0=9.396401299266444e-07
Cn6_3 n6_3 0 2n
Xn6_3 n6_3 0 ml w0=9.396401299266444e-07
Cn6_4 n6_4 0 2n
Xn6_4 n6_4 0 ml w0=9.396401299266444e-07
Cn6_5 n6_5 0 2n
Xn6_5 n6_5 0 ml w0=9.396401299266444e-07
Cn6_6 n6_6 0 2n
Xn6_6 n6_6 0 ml w0=9.396401299266444e-07
Cn6_7 n6_7 0 2n
Xn6_7 n6_7 0 ml w0=9.396401299266444e-07
Cn6_8 n6_8 0 2n
Xn6_8 n6_8 0 ml w0=9.396401299266444e-07
Cn6_9 n6_9 0 2n
Xn6_9 n6_9 0 ml w0=9.396401299266444e-07
Cn6_10 n6_10 0 2n
Xn6_10 n6_10 0 ml w0=9.396401299266444e-07
Cn6_11 n6_11 0 2n
Xn6_11 n6_11 0 ml w0=9.396401299266444e-07
Cn6_12 n6_12 0 2n
Xn6_12 n6_12 0 ml w0=9.396401299266444e-07
Cn6_13 n6_13 0 2n
Xn6_13 n6_13 0 ml w0=9.396401299266444e-07
Cn6_14 n6_14 0 2n
Xn6_14 n6_14 0 ml w0=9.396401299266444e-07
Cn6_15 n6_15 0 2n
Xn6_15 n6_15 0 ml w0=9.396401299266444e-07
Cn7_1 n7_1 0 2n
Xn7_1 n7_1 0 ml w0=9.396401299266444e-07
Cn7_2 n7_2 0 2n
Xn7_2 n7_2 0 ml w0=9.396401299266444e-07
Cn7_3 n7_3 0 2n
Xn7_3 n7_3 0 ml w0=9.396401299266444e-07
Cn7_4 n7_4 0 2n
Xn7_4 n7_4 0 ml w0=9.396401299266444e-07
Cn7_5 n7_5 0 2n
Xn7_5 n7_5 0 ml w0=9.396401299266444e-07
Cn7_6 n7_6 0 2n
Xn7_6 n7_6 0 ml w0=9.396401299266444e-07
Cn7_7 n7_7 0 2n
Xn7_7 n7_7 0 ml w0=9.396401299266444e-07
Cn7_8 n7_8 0 2n
Xn7_8 n7_8 0 ml w0=9.396401299266444e-07
Cn7_9 n7_9 0 2n
Xn7_9 n7_9 0 ml w0=9.396401299266444e-07
Cn7_10 n7_10 0 2n
Xn7_10 n7_10 0 ml w0=9.396401299266444e-07
Cn7_11 n7_11 0 2n
Xn7_11 n7_11 0 ml w0=9.396401299266444e-07
Cn7_12 n7_12 0 2n
Xn7_12 n7_12 0 ml w0=9.396401299266444e-07
Cn7_13 n7_13 0 2n
Xn7_13 n7_13 0 ml w0=9.396401299266444e-07
Cn7_14 n7_14 0 2n
Xn7_14 n7_14 0 ml w0=9.396401299266444e-07
Cn7_15 n7_15 0 2n
Xn7_15 n7_15 0 ml w0=9.396401299266444e-07
Cn8_1 n8_1 0 2n
Xn8_1 n8_1 0 ml w0=9.396401299266444e-07
Cn8_2 n8_2 0 2n
Xn8_2 n8_2 0 ml w0=9.396401299266444e-07
Cn8_3 n8_3 0 2n
Xn8_3 n8_3 0 ml w0=9.396401299266444e-07
Cn8_4 n8_4 0 2n
Xn8_4 n8_4 0 ml w0=9.396401299266444e-07
Cn8_5 n8_5 0 2n
Xn8_5 n8_5 0 ml w0=9.396401299266444e-07
Cn8_6 n8_6 0 2n
Xn8_6 n8_6 0 ml w0=9.396401299266444e-07
Cn8_7 n8_7 0 2n
Xn8_7 n8_7 0 ml w0=9.396401299266444e-07
Cn8_8 n8_8 0 2n
Xn8_8 n8_8 0 ml w0=9.396401299266444e-07
Cn8_9 n8_9 0 2n
Xn8_9 n8_9 0 ml w0=9.396401299266444e-07
Cn8_10 n8_10 0 2n
Xn8_10 n8_10 0 ml w0=9.396401299266444e-07
Cn8_11 n8_11 0 2n
Xn8_11 n8_11 0 ml w0=9.396401299266444e-07
Cn8_12 n8_12 0 2n
Xn8_12 n8_12 0 ml w0=9.396401299266444e-07
Cn8_13 n8_13 0 2n
Xn8_13 n8_13 0 ml w0=9.396401299266444e-07
Cn8_14 n8_14 0 2n
Xn8_14 n8_14 0 ml w0=9.396401299266444e-07
Cn8_15 n8_15 0 2n
Xn8_15 n8_15 0 ml w0=9.396401299266444e-07
Cn9_1 n9_1 0 2n
Xn9_1 n9_1 0 ml w0=9.396401299266444e-07
Cn9_2 n9_2 0 2n
Xn9_2 n9_2 0 ml w0=9.396401299266444e-07
Cn9_3 n9_3 0 2n
Xn9_3 n9_3 0 ml w0=9.396401299266444e-07
Cn9_4 n9_4 0 2n
Xn9_4 n9_4 0 ml w0=9.396401299266444e-07
Cn9_5 n9_5 0 2n
Xn9_5 n9_5 0 ml w0=9.396401299266444e-07
Cn9_6 n9_6 0 2n
Xn9_6 n9_6 0 ml w0=9.396401299266444e-07
Cn9_7 n9_7 0 2n
Xn9_7 n9_7 0 ml w0=9.396401299266444e-07
Cn9_8 n9_8 0 2n
Xn9_8 n9_8 0 ml w0=9.396401299266444e-07
Cn9_9 n9_9 0 2n
Xn9_9 n9_9 0 ml w0=9.396401299266444e-07
Cn9_10 n9_10 0 2n
Xn9_10 n9_10 0 ml w0=9.396401299266444e-07
Cn9_11 n9_11 0 2n
Xn9_11 n9_11 0 ml w0=9.396401299266444e-07
Cn9_12 n9_12 0 2n
Xn9_12 n9_12 0 ml w0=9.396401299266444e-07
Cn9_13 n9_13 0 2n
Xn9_13 n9_13 0 ml w0=9.396401299266444e-07
Cn9_14 n9_14 0 2n
Xn9_14 n9_14 0 ml w0=9.396401299266444e-07
Cn9_15 n9_15 0 2n
Xn9_15 n9_15 0 ml w0=9.396401299266444e-07
Cn10_1 n10_1 0 2n
Xn10_1 n10_1 0 ml w0=9.396401299266444e-07
Cn10_2 n10_2 0 2n
Xn10_2 n10_2 0 ml w0=9.396401299266444e-07
Cn10_3 n10_3 0 2n
Xn10_3 n10_3 0 ml w0=9.396401299266444e-07
Cn10_4 n10_4 0 2n
Xn10_4 n10_4 0 ml w0=9.396401299266444e-07
Cn10_5 n10_5 0 2n
Xn10_5 n10_5 0 ml w0=9.396401299266444e-07
Cn10_6 n10_6 0 2n
Xn10_6 n10_6 0 ml w0=9.396401299266444e-07
Cn10_7 n10_7 0 2n
Xn10_7 n10_7 0 ml w0=9.396401299266444e-07
Cn10_8 n10_8 0 2n
Xn10_8 n10_8 0 ml w0=9.396401299266444e-07
Cn10_9 n10_9 0 2n
Xn10_9 n10_9 0 ml w0=9.396401299266444e-07
Cn10_10 n10_10 0 2n
Xn10_10 n10_10 0 ml w0=9.396401299266444e-07
Cn10_11 n10_11 0 2n
Xn10_11 n10_11 0 ml w0=9.396401299266444e-07
Cn10_12 n10_12 0 2n
Xn10_12 n10_12 0 ml w0=9.396401299266444e-07
Cn10_13 n10_13 0 2n
Xn10_13 n10_13 0 ml w0=9.396401299266444e-07
Cn10_14 n10_14 0 2n
Xn10_14 n10_14 0 ml w0=9.396401299266444e-07
Cn10_15 n10_15 0 2n
Xn10_15 n10_15 0 ml w0=9.396401299266444e-07
Cn11_1 n11_1 0 2n
Xn11_1 n11_1 0 ml w0=9.396401299266444e-07
Cn11_2 n11_2 0 2n
Xn11_2 n11_2 0 ml w0=9.396401299266444e-07
Cn11_3 n11_3 0 2n
Xn11_3 n11_3 0 ml w0=9.396401299266444e-07
Cn11_4 n11_4 0 2n
Xn11_4 n11_4 0 ml w0=9.396401299266444e-07
Cn11_5 n11_5 0 2n
Xn11_5 n11_5 0 ml w0=9.396401299266444e-07
Cn11_6 n11_6 0 2n
Xn11_6 n11_6 0 ml w0=9.396401299266444e-07
Cn11_7 n11_7 0 2n
Xn11_7 n11_7 0 ml w0=9.396401299266444e-07
Cn11_8 n11_8 0 2n
Xn11_8 n11_8 0 ml w0=9.396401299266444e-07
Cn11_9 n11_9 0 2n
Xn11_9 n11_9 0 ml w0=9.396401299266444e-07
Cn11_10 n11_10 0 2n
Xn11_10 n11_10 0 ml w0=9.396401299266444e-07
Cn11_11 n11_11 0 2n
Xn11_11 n11_11 0 ml w0=9.396401299266444e-07
Cn11_12 n11_12 0 2n
Xn11_12 n11_12 0 ml w0=9.396401299266444e-07
Cn11_13 n11_13 0 2n
Xn11_13 n11_13 0 ml w0=9.396401299266444e-07
Cn11_14 n11_14 0 2n
Xn11_14 n11_14 0 ml w0=9.396401299266444e-07
Cn11_15 n11_15 0 2n
Xn11_15 n11_15 0 ml w0=9.396401299266444e-07
Cn12_1 n12_1 0 2n
Xn12_1 n12_1 0 ml w0=9.396401299266444e-07
Cn12_2 n12_2 0 2n
Xn12_2 n12_2 0 ml w0=9.396401299266444e-07
Cn12_3 n12_3 0 2n
Xn12_3 n12_3 0 ml w0=9.396401299266444e-07
Cn12_4 n12_4 0 2n
Xn12_4 n12_4 0 ml w0=9.396401299266444e-07
Cn12_5 n12_5 0 2n
Xn12_5 n12_5 0 ml w0=9.396401299266444e-07
Cn12_6 n12_6 0 2n
Xn12_6 n12_6 0 ml w0=9.396401299266444e-07
Cn12_7 n12_7 0 2n
Xn12_7 n12_7 0 ml w0=9.396401299266444e-07
Cn12_8 n12_8 0 2n
Xn12_8 n12_8 0 ml w0=9.396401299266444e-07
Cn12_9 n12_9 0 2n
Xn12_9 n12_9 0 ml w0=9.396401299266444e-07
Cn12_10 n12_10 0 2n
Xn12_10 n12_10 0 ml w0=9.396401299266444e-07
Cn12_11 n12_11 0 2n
Xn12_11 n12_11 0 ml w0=9.396401299266444e-07
Cn12_12 n12_12 0 2n
Xn12_12 n12_12 0 ml w0=9.396401299266444e-07
Cn12_13 n12_13 0 2n
Xn12_13 n12_13 0 ml w0=9.396401299266444e-07
Cn12_14 n12_14 0 2n
Xn12_14 n12_14 0 ml w0=9.396401299266444e-07
Cn12_15 n12_15 0 2n
Xn12_15 n12_15 0 ml w0=9.396401299266444e-07
Cn13_1 n13_1 0 2n
Xn13_1 n13_1 0 ml w0=9.396401299266444e-07
Cn13_2 n13_2 0 2n
Xn13_2 n13_2 0 ml w0=9.396401299266444e-07
Cn13_3 n13_3 0 2n
Xn13_3 n13_3 0 ml w0=9.396401299266444e-07
Cn13_4 n13_4 0 2n
Xn13_4 n13_4 0 ml w0=9.396401299266444e-07
Cn13_5 n13_5 0 2n
Xn13_5 n13_5 0 ml w0=9.396401299266444e-07
Cn13_6 n13_6 0 2n
Xn13_6 n13_6 0 ml w0=9.396401299266444e-07
Cn13_7 n13_7 0 2n
Xn13_7 n13_7 0 ml w0=9.396401299266444e-07
Cn13_8 n13_8 0 2n
Xn13_8 n13_8 0 ml w0=9.396401299266444e-07
Cn13_9 n13_9 0 2n
Xn13_9 n13_9 0 ml w0=9.396401299266444e-07
Cn13_10 n13_10 0 2n
Xn13_10 n13_10 0 ml w0=9.396401299266444e-07
Cn13_11 n13_11 0 2n
Xn13_11 n13_11 0 ml w0=9.396401299266444e-07
Cn13_12 n13_12 0 2n
Xn13_12 n13_12 0 ml w0=9.396401299266444e-07
Cn13_13 n13_13 0 2n
Xn13_13 n13_13 0 ml w0=9.396401299266444e-07
Cn13_14 n13_14 0 2n
Xn13_14 n13_14 0 ml w0=9.396401299266444e-07
Cn13_15 n13_15 0 2n
Xn13_15 n13_15 0 ml w0=9.396401299266444e-07
Cn14_1 n14_1 0 2n
Xn14_1 n14_1 0 ml w0=9.396401299266444e-07
Cn14_2 n14_2 0 2n
Xn14_2 n14_2 0 ml w0=9.396401299266444e-07
Cn14_3 n14_3 0 2n
Xn14_3 n14_3 0 ml w0=9.396401299266444e-07
Cn14_4 n14_4 0 2n
Xn14_4 n14_4 0 ml w0=9.396401299266444e-07
Cn14_5 n14_5 0 2n
Xn14_5 n14_5 0 ml w0=9.396401299266444e-07
Cn14_6 n14_6 0 2n
Xn14_6 n14_6 0 ml w0=9.396401299266444e-07
Cn14_7 n14_7 0 2n
Xn14_7 n14_7 0 ml w0=9.396401299266444e-07
Cn14_8 n14_8 0 2n
Xn14_8 n14_8 0 ml w0=9.396401299266444e-07
Cn14_9 n14_9 0 2n
Xn14_9 n14_9 0 ml w0=9.396401299266444e-07
Cn14_10 n14_10 0 2n
Xn14_10 n14_10 0 ml w0=9.396401299266444e-07
Cn14_11 n14_11 0 2n
Xn14_11 n14_11 0 ml w0=9.396401299266444e-07
Cn14_12 n14_12 0 2n
Xn14_12 n14_12 0 ml w0=9.396401299266444e-07
Cn14_13 n14_13 0 2n
Xn14_13 n14_13 0 ml w0=9.396401299266444e-07
Cn14_14 n14_14 0 2n
Xn14_14 n14_14 0 ml w0=9.396401299266444e-07
Cn14_15 n14_15 0 2n
Xn14_15 n14_15 0 ml w0=9.396401299266444e-07
Cn15_1 n15_1 0 2n
Xn15_1 n15_1 0 ml w0=9.396401299266444e-07
Cn15_2 n15_2 0 2n
Xn15_2 n15_2 0 ml w0=9.396401299266444e-07
Cn15_3 n15_3 0 2n
Xn15_3 n15_3 0 ml w0=9.396401299266444e-07
Cn15_4 n15_4 0 2n
Xn15_4 n15_4 0 ml w0=9.396401299266444e-07
Cn15_5 n15_5 0 2n
Xn15_5 n15_5 0 ml w0=9.396401299266444e-07
Cn15_6 n15_6 0 2n
Xn15_6 n15_6 0 ml w0=9.396401299266444e-07
Cn15_7 n15_7 0 2n
Xn15_7 n15_7 0 ml w0=9.396401299266444e-07
Cn15_8 n15_8 0 2n
Xn15_8 n15_8 0 ml w0=9.396401299266444e-07
Cn15_9 n15_9 0 2n
Xn15_9 n15_9 0 ml w0=9.396401299266444e-07
Cn15_10 n15_10 0 2n
Xn15_10 n15_10 0 ml w0=9.396401299266444e-07
Cn15_11 n15_11 0 2n
Xn15_11 n15_11 0 ml w0=9.396401299266444e-07
Cn15_12 n15_12 0 2n
Xn15_12 n15_12 0 ml w0=9.396401299266444e-07
Cn15_13 n15_13 0 2n
Xn15_13 n15_13 0 ml w0=9.396401299266444e-07
Cn15_14 n15_14 0 2n
Xn15_14 n15_14 0 ml w0=9.396401299266444e-07
Cn15_15 n15_15 0 2n
Xn15_15 n15_15 0 ml w0=9.396401299266444e-07
I1 0 n3_15 PULSE(0 2.4u 0 1u 1u 2m 6m)
I2 0 n15_15 PULSE(0 2.4u 0 1u 1u 2m 6m)
X1_1_2_1p n1_1 m1_1_2_1 n5_3 n10_8 prune eta2=0.5 factor=0.083511258828974 factor2=0.04603538413957382 w0=0
X1_1_2_1m m1_1_2_1 p1_1_2_1 growth w0=0
R1_1_2_1p p1_1_2_1 n2_1 2647391.233933647
X1_1_2_1n q1_1_2_1 m1_1_2_1 growth w0=0
R1_1_2_1n q1_1_2_1 n2_1 2647391.233933647
X1_1_1_2p n1_1 m1_1_1_2 n5_3 n10_8 prune eta2=0.5 factor=0.07463303884748085 factor2=0.04556802174054626 w0=0
X1_1_1_2m m1_1_1_2 p1_1_1_2 growth w0=0
R1_1_1_2p p1_1_1_2 n1_2 2647391.233933647
X1_1_1_2n q1_1_1_2 m1_1_1_2 growth w0=0
R1_1_1_2n q1_1_1_2 n1_2 2647391.233933647
X1_2_2_2p n1_2 m1_2_2_2 n5_3 n10_8 prune eta2=0.5 factor=0.08408857567321473 factor2=0.049090909090909095 w0=0
X1_2_2_2m m1_2_2_2 p1_2_2_2 growth w0=0
R1_2_2_2p p1_2_2_2 n2_2 2647391.233933647
X1_2_2_2n q1_2_2_2 m1_2_2_2 growth w0=0
R1_2_2_2n q1_2_2_2 n2_2 2647391.233933647
X1_2_1_3p n1_2 m1_2_1_3 n5_3 n10_8 prune eta2=0.5 factor=0.075 factor2=0.04802324646062467 w0=0
X1_2_1_3m m1_2_1_3 p1_2_1_3 growth w0=0
R1_2_1_3p p1_2_1_3 n1_3 2647391.233933647
X1_2_1_3n q1_2_1_3 m1_2_1_3 growth w0=0
R1_2_1_3n q1_2_1_3 n1_3 2647391.233933647
X1_3_2_3p n1_3 m1_3_2_3 n5_3 n10_8 prune eta2=0.5 factor=0.08333333333333334 factor2=0.052227794293251445 w0=0
X1_3_2_3m m1_3_2_3 p1_3_2_3 growth w0=0
R1_3_2_3p p1_3_2_3 n2_3 2647391.233933647
X1_3_2_3n q1_3_2_3 m1_3_2_3 growth w0=0
R1_3_2_3n q1_3_2_3 n2_3 2647391.233933647
X1_3_1_4p n1_3 m1_3_1_4 n5_3 n10_8 prune eta2=0.5 factor=0.07463303884748085 factor2=0.05036398877740481 w0=0
X1_3_1_4m m1_3_1_4 p1_3_1_4 growth w0=0
R1_3_1_4p p1_3_1_4 n1_4 2647391.233933647
X1_3_1_4n q1_3_1_4 m1_3_1_4 growth w0=0
R1_3_1_4n q1_3_1_4 n1_4 2647391.233933647
X1_4_2_4p n1_4 m1_4_2_4 n5_3 n10_8 prune eta2=0.5 factor=0.08408857567321473 factor2=0.055308222158221995 w0=0
X1_4_2_4m m1_4_2_4 p1_4_2_4 growth w0=0
R1_4_2_4p p1_4_2_4 n2_4 2647391.233933647
X1_4_2_4n q1_4_2_4 m1_4_2_4 growth w0=0
R1_4_2_4n q1_4_2_4 n2_4 2647391.233933647
X1_4_1_5p n1_4 m1_4_1_5 n5_3 n10_8 prune eta2=0.5 factor=0.07309759905262272 factor2=0.052446720666042994 w0=0
X1_4_1_5m m1_4_1_5 p1_4_1_5 growth w0=0
R1_4_1_5p p1_4_1_5 n1_5 2647391.233933647
X1_4_1_5n q1_4_1_5 m1_4_1_5 growth w0=0
R1_4_1_5n q1_4_1_5 n1_5 2647391.233933647
X1_5_2_5p n1_5 m1_5_2_5 n5_3 n10_8 prune eta2=0.5 factor=0.083511258828974 factor2=0.058130165845768654 w0=0
X1_5_2_5m m1_5_2_5 p1_5_2_5 growth w0=0
R1_5_2_5p p1_5_2_5 n2_5 2647391.233933647
X1_5_2_5n q1_5_2_5 m1_5_2_5 growth w0=0
R1_5_2_5n q1_5_2_5 n2_5 2647391.233933647
X1_5_1_6p n1_5 m1_5_1_6 n5_3 n10_8 prune eta2=0.5 factor=0.06999999999999999 factor2=0.054106245026998005 w0=0
X1_5_1_6m m1_5_1_6 p1_5_1_6 growth w0=0
R1_5_1_6p p1_5_1_6 n1_6 2647391.233933647
X1_5_1_6n q1_5_1_6 m1_5_1_6 growth w0=0
R1_5_1_6n q1_5_1_6 n1_6 2647391.233933647
X1_6_2_6p n1_6 m1_6_2_6 n5_3 n10_8 prune eta2=0.5 factor=0.07947648742939425 factor2=0.06043810964594869 w0=0
X1_6_2_6m m1_6_2_6 p1_6_2_6 growth w0=0
R1_6_2_6p p1_6_2_6 n2_6 2647391.233933647
X1_6_2_6n q1_6_2_6 m1_6_2_6 growth w0=0
R1_6_2_6n q1_6_2_6 n2_6 2647391.233933647
X1_6_1_7p n1_6 m1_6_1_7 n5_3 n10_8 prune eta2=0.5 factor=0.0657217333597715 factor2=0.05518217762500037 w0=0
X1_6_1_7m m1_6_1_7 p1_6_1_7 growth w0=0
R1_6_1_7p p1_6_1_7 n1_7 2647391.233933647
X1_6_1_7n q1_6_1_7 m1_6_1_7 growth w0=0
R1_6_1_7n q1_6_1_7 n1_7 2647391.233933647
X1_7_2_7p n1_7 m1_7_2_7 n5_3 n10_8 prune eta2=0.5 factor=0.07333333333333333 factor2=0.06196452110886949 w0=0
X1_7_2_7m m1_7_2_7 p1_7_2_7 growth w0=0
R1_7_2_7p p1_7_2_7 n2_7 2647391.233933647
X1_7_2_7n q1_7_2_7 m1_7_2_7 growth w0=0
R1_7_2_7n q1_7_2_7 n2_7 2647391.233933647
X1_7_1_8p n1_7 m1_7_1_8 n5_3 n10_8 prune eta2=0.5 factor=0.06094987706860226 factor2=0.05555555555555556 w0=0
X1_7_1_8m m1_7_1_8 p1_7_1_8 growth w0=0
R1_7_1_8p p1_7_1_8 n1_8 2647391.233933647
X1_7_1_8n q1_7_1_8 m1_7_1_8 growth w0=0
R1_7_1_8n q1_7_1_8 n1_8 2647391.233933647
X1_8_2_8p n1_8 m1_8_2_8 n5_3 n10_8 prune eta2=0.5 factor=0.06673774899296092 factor2=0.0625 w0=0
X1_8_2_8m m1_8_2_8 p1_8_2_8 growth w0=0
R1_8_2_8p p1_8_2_8 n2_8 2647391.233933647
X1_8_2_8n q1_8_2_8 m1_8_2_8 growth w0=0
R1_8_2_8n q1_8_2_8 n2_8 2647391.233933647
X1_8_1_9p n1_8 m1_8_1_9 n5_3 n10_8 prune eta2=0.5 factor=0.056209072859076725 factor2=0.05518217762500037 w0=0
X1_8_1_9m m1_8_1_9 p1_8_1_9 growth w0=0
R1_8_1_9p p1_8_1_9 n1_9 2647391.233933647
X1_8_1_9n q1_8_1_9 m1_8_1_9 growth w0=0
R1_8_1_9n q1_8_1_9 n1_9 2647391.233933647
X1_9_2_9p n1_9 m1_9_2_9 n5_3 n10_8 prune eta2=0.5 factor=0.06054155685984179 factor2=0.06196452110886949 w0=0
X1_9_2_9m m1_9_2_9 p1_9_2_9 growth w0=0
R1_9_2_9p p1_9_2_9 n2_9 2647391.233933647
X1_9_2_9n q1_9_2_9 m1_9_2_9 growth w0=0
R1_9_2_9n q1_9_2_9 n2_9 2647391.233933647
X1_9_1_10p n1_9 m1_9_1_10 n5_3 n10_8 prune eta2=0.5 factor=0.05177857243343889 factor2=0.054106245026998005 w0=0
X1_9_1_10m m1_9_1_10 p1_9_1_10 growth w0=0
R1_9_1_10p p1_9_1_10 n1_10 2647391.233933647
X1_9_1_10n q1_9_1_10 m1_9_1_10 growth w0=0
R1_9_1_10n q1_9_1_10 n1_10 2647391.233933647
X1_10_2_10p n1_10 m1_10_2_10 n5_3 n10_8 prune eta2=0.5 factor=0.0550313854843489 factor2=0.06043810964594869 w0=0
X1_10_2_10m m1_10_2_10 p1_10_2_10 growth w0=0
R1_10_2_10p p1_10_2_10 n2_10 2647391.233933647
X1_10_2_10n q1_10_2_10 m1_10_2_10 growth w0=0
R1_10_2_10n q1_10_2_10 n2_10 2647391.233933647
X1_10_1_11p n1_10 m1_10_1_11 n5_3 n10_8 prune eta2=0.5 factor=0.04776619186391899 factor2=0.052446720666042994 w0=0
X1_10_1_11m m1_10_1_11 p1_10_1_11 growth w0=0
R1_10_1_11p p1_10_1_11 n1_11 2647391.233933647
X1_10_1_11n q1_10_1_11 m1_10_1_11 growth w0=0
R1_10_1_11n q1_10_1_11 n1_11 2647391.233933647
X1_11_2_11p n1_11 m1_11_2_11 n5_3 n10_8 prune eta2=0.5 factor=0.050235945792639576 factor2=0.058130165845768654 w0=0
X1_11_2_11m m1_11_2_11 p1_11_2_11 growth w0=0
R1_11_2_11p p1_11_2_11 n2_11 2647391.233933647
X1_11_2_11n q1_11_2_11 m1_11_2_11 growth w0=0
R1_11_2_11n q1_11_2_11 n2_11 2647391.233933647
X1_11_1_12p n1_11 m1_11_1_12 n5_3 n10_8 prune eta2=0.5 factor=0.04418727317262875 factor2=0.05036398877740481 w0=0
X1_11_1_12m m1_11_1_12 p1_11_1_12 growth w0=0
R1_11_1_12p p1_11_1_12 n1_12 2647391.233933647
X1_11_1_12n q1_11_1_12 m1_11_1_12 growth w0=0
R1_11_1_12n q1_11_1_12 n1_12 2647391.233933647
X1_12_2_12p n1_12 m1_12_2_12 n5_3 n10_8 prune eta2=0.5 factor=0.04608954240349232 factor2=0.055308222158221995 w0=0
X1_12_2_12m m1_12_2_12 p1_12_2_12 growth w0=0
R1_12_2_12p p1_12_2_12 n2_12 2647391.233933647
X1_12_2_12n q1_12_2_12 m1_12_2_12 growth w0=0
R1_12_2_12n q1_12_2_12 n2_12 2647391.233933647
X1_12_1_13p n1_12 m1_12_1_13 n5_3 n10_8 prune eta2=0.5 factor=0.04101487694145911 factor2=0.04802324646062467 w0=0
X1_12_1_13m m1_12_1_13 p1_12_1_13 growth w0=0
R1_12_1_13p p1_12_1_13 n1_13 2647391.233933647
X1_12_1_13n q1_12_1_13 m1_12_1_13 growth w0=0
R1_12_1_13n q1_12_1_13 n1_13 2647391.233933647
X1_13_2_13p n1_13 m1_13_2_13 n5_3 n10_8 prune eta2=0.5 factor=0.042502229440388985 factor2=0.052227794293251445 w0=0
X1_13_2_13m m1_13_2_13 p1_13_2_13 growth w0=0
R1_13_2_13p p1_13_2_13 n2_13 2647391.233933647
X1_13_2_13n q1_13_2_13 m1_13_2_13 growth w0=0
R1_13_2_13n q1_13_2_13 n2_13 2647391.233933647
X1_13_1_14p n1_13 m1_13_1_14 n5_3 n10_8 prune eta2=0.5 factor=0.038206448264429746 factor2=0.04556802174054626 w0=0
X1_13_1_14m m1_13_1_14 p1_13_1_14 growth w0=0
R1_13_1_14p p1_13_1_14 n1_14 2647391.233933647
X1_13_1_14n q1_13_1_14 m1_13_1_14 growth w0=0
R1_13_1_14n q1_13_1_14 n1_14 2647391.233933647
X1_14_2_14p n1_14 m1_14_2_14 n5_3 n10_8 prune eta2=0.5 factor=0.03938648747393874 factor2=0.049090909090909095 w0=0
X1_14_2_14m m1_14_2_14 p1_14_2_14 growth w0=0
R1_14_2_14p p1_14_2_14 n2_14 2647391.233933647
X1_14_2_14n q1_14_2_14 m1_14_2_14 growth w0=0
R1_14_2_14n q1_14_2_14 n2_14 2647391.233933647
X1_14_1_15p n1_14 m1_14_1_15 n5_3 n10_8 prune eta2=0.5 factor=0.035716612813385784 factor2=0.04310804534549201 w0=0
X1_14_1_15m m1_14_1_15 p1_14_1_15 growth w0=0
R1_14_1_15p p1_14_1_15 n1_15 2647391.233933647
X1_14_1_15n q1_14_1_15 m1_14_1_15 growth w0=0
R1_14_1_15n q1_14_1_15 n1_15 2647391.233933647
X1_15_2_15p n1_15 m1_15_2_15 n5_3 n10_8 prune eta2=0.5 factor=0.03666575360182205 factor2=0.04603538413957382 w0=0
X1_15_2_15m m1_15_2_15 p1_15_2_15 growth w0=0
R1_15_2_15p p1_15_2_15 n2_15 2647391.233933647
X1_15_2_15n q1_15_2_15 m1_15_2_15 growth w0=0
R1_15_2_15n q1_15_2_15 n2_15 2647391.233933647
X2_1_3_1p n2_1 m2_1_3_1 n5_3 n10_8 prune eta2=0.5 factor=0.09795145311140303 factor2=0.04915037704314248 w0=0
X2_1_3_1m m2_1_3_1 p2_1_3_1 growth w0=0
R2_1_3_1p p2_1_3_1 n3_1 2647391.233933647
X2_1_3_1n q2_1_3_1 m2_1_3_1 growth w0=0
R2_1_3_1n q2_1_3_1 n3_1 2647391.233933647
X2_1_2_2p n2_1 m2_1_2_2 n5_3 n10_8 prune eta2=0.5 factor=0.08408857567321473 factor2=0.049090909090909095 w0=0
X2_1_2_2m m2_1_2_2 p2_1_2_2 growth w0=0
R2_1_2_2p p2_1_2_2 n2_2 2647391.233933647
X2_1_2_2n q2_1_2_2 m2_1_2_2 growth w0=0
R2_1_2_2n q2_1_2_2 n2_2 2647391.233933647
X2_2_3_2p n2_2 m2_2_3_2 n5_3 n10_8 prune eta2=0.5 factor=0.09270509831248422 factor2=0.05295504832429591 w0=0
X2_2_3_2m m2_2_3_2 p2_2_3_2 growth w0=0
R2_2_3_2p p2_2_3_2 n3_2 2647391.233933647
X2_2_3_2n q2_2_3_2 m2_2_3_2 growth w0=0
R2_2_3_2n q2_2_3_2 n3_2 2647391.233933647
X2_2_2_3p n2_2 m2_2_2_3 n5_3 n10_8 prune eta2=0.5 factor=0.08333333333333334 factor2=0.052227794293251445 w0=0
X2_2_2_3m m2_2_2_3 p2_2_2_3 growth w0=0
R2_2_2_3p p2_2_2_3 n2_3 2647391.233933647
X2_2_2_3n q2_2_2_3 m2_2_2_3 growth w0=0
R2_2_2_3n q2_2_2_3 n2_3 2647391.233933647
X2_3_3_3p n2_3 m2_3_3_3 n5_3 n10_8 prune eta2=0.5 factor=0.08333333333333333 factor2=0.056996329751060046 w0=0
X2_3_3_3m m2_3_3_3 p2_3_3_3 growth w0=0
R2_3_3_3p p2_3_3_3 n3_3 2647391.233933647
X2_3_3_3n q2_3_3_3 m2_3_3_3 growth w0=0
R2_3_3_3n q2_3_3_3 n3_3 2647391.233933647
X2_3_2_4p n2_3 m2_3_2_4 n5_3 n10_8 prune eta2=0.5 factor=0.08408857567321473 factor2=0.055308222158221995 w0=0
X2_3_2_4m m2_3_2_4 p2_3_2_4 growth w0=0
R2_3_2_4p p2_3_2_4 n2_4 2647391.233933647
X2_3_2_4n q2_3_2_4 m2_3_2_4 growth w0=0
R2_3_2_4n q2_3_2_4 n2_4 2647391.233933647
X2_4_3_4p n2_4 m2_4_3_4 n5_3 n10_8 prune eta2=0.5 factor=0.09270509831248422 factor2=0.06111569205258361 w0=0
X2_4_3_4m m2_4_3_4 p2_4_3_4 growth w0=0
R2_4_3_4p p2_4_3_4 n3_4 2647391.233933647
X2_4_3_4n q2_4_3_4 m2_4_3_4 growth w0=0
R2_4_3_4n q2_4_3_4 n3_4 2647391.233933647
X2_4_2_5p n2_4 m2_4_2_5 n5_3 n10_8 prune eta2=0.5 factor=0.083511258828974 factor2=0.058130165845768654 w0=0
X2_4_2_5m m2_4_2_5 p2_4_2_5 growth w0=0
R2_4_2_5p p2_4_2_5 n2_5 2647391.233933647
X2_4_2_5n q2_4_2_5 m2_4_2_5 growth w0=0
R2_4_2_5n q2_4_2_5 n2_5 2647391.233933647
X2_5_3_5p n2_5 m2_5_3_5 n5_3 n10_8 prune eta2=0.5 factor=0.09795145311140303 factor2=0.0650370919360487 w0=0
X2_5_3_5m m2_5_3_5 p2_5_3_5 growth w0=0
R2_5_3_5p p2_5_3_5 n3_5 2647391.233933647
X2_5_3_5n q2_5_3_5 m2_5_3_5 growth w0=0
R2_5_3_5n q2_5_3_5 n3_5 2647391.233933647
X2_5_2_6p n2_5 m2_5_2_6 n5_3 n10_8 prune eta2=0.5 factor=0.07947648742939425 factor2=0.06043810964594869 w0=0
X2_5_2_6m m2_5_2_6 p2_5_2_6 growth w0=0
R2_5_2_6p p2_5_2_6 n2_6 2647391.233933647
X2_5_2_6n q2_5_2_6 m2_5_2_6 growth w0=0
R2_5_2_6n q2_5_2_6 n2_6 2647391.233933647
X2_6_3_6p n2_6 m2_6_3_6 n5_3 n10_8 prune eta2=0.5 factor=0.09186238471187141 factor2=0.06836113812714643 w0=0
X2_6_3_6m m2_6_3_6 p2_6_3_6 growth w0=0
R2_6_3_6p p2_6_3_6 n3_6 2647391.233933647
X2_6_3_6n q2_6_3_6 m2_6_3_6 growth w0=0
R2_6_3_6n q2_6_3_6 n3_6 2647391.233933647
X2_6_2_7p n2_6 m2_6_2_7 n5_3 n10_8 prune eta2=0.5 factor=0.07333333333333333 factor2=0.06196452110886949 w0=0
X2_6_2_7m m2_6_2_7 p2_6_2_7 growth w0=0
R2_6_2_7p p2_6_2_7 n2_7 2647391.233933647
X2_6_2_7n q2_6_2_7 m2_6_2_7 growth w0=0
R2_6_2_7n q2_6_2_7 n2_7 2647391.233933647
X2_7_3_7p n2_7 m2_7_3_7 n5_3 n10_8 prune eta2=0.5 factor=0.08223479893420056 factor2=0.07062262556659839 w0=0
X2_7_3_7m m2_7_3_7 p2_7_3_7 growth w0=0
R2_7_3_7p p2_7_3_7 n3_7 2647391.233933647
X2_7_3_7n q2_7_3_7 m2_7_3_7 growth w0=0
R2_7_3_7n q2_7_3_7 n3_7 2647391.233933647
X2_7_2_8p n2_7 m2_7_2_8 n5_3 n10_8 prune eta2=0.5 factor=0.06673774899296092 factor2=0.0625 w0=0
X2_7_2_8m m2_7_2_8 p2_7_2_8 growth w0=0
R2_7_2_8p p2_7_2_8 n2_8 2647391.233933647
X2_7_2_8n q2_7_2_8 m2_7_2_8 growth w0=0
R2_7_2_8n q2_7_2_8 n2_8 2647391.233933647
X2_8_3_8p n2_8 m2_8_3_8 n5_3 n10_8 prune eta2=0.5 factor=0.07290606514324606 factor2=0.07142857142857142 w0=0
X2_8_3_8m m2_8_3_8 p2_8_3_8 growth w0=0
R2_8_3_8p p2_8_3_8 n3_8 2647391.233933647
X2_8_3_8n q2_8_3_8 m2_8_3_8 growth w0=0
R2_8_3_8n q2_8_3_8 n3_8 2647391.233933647
X2_8_2_9p n2_8 m2_8_2_9 n5_3 n10_8 prune eta2=0.5 factor=0.06054155685984179 factor2=0.06196452110886949 w0=0
X2_8_2_9m m2_8_2_9 p2_8_2_9 growth w0=0
R2_8_2_9p p2_8_2_9 n2_9 2647391.233933647
X2_8_2_9n q2_8_2_9 m2_8_2_9 growth w0=0
R2_8_2_9n q2_8_2_9 n2_9 2647391.233933647
X2_9_3_9p n2_9 m2_9_3_9 n5_3 n10_8 prune eta2=0.5 factor=0.06485035326051179 factor2=0.07062262556659839 w0=0
X2_9_3_9m m2_9_3_9 p2_9_3_9 growth w0=0
R2_9_3_9p p2_9_3_9 n3_9 2647391.233933647
X2_9_3_9n q2_9_3_9 m2_9_3_9 growth w0=0
R2_9_3_9n q2_9_3_9 n3_9 2647391.233933647
X2_9_2_10p n2_9 m2_9_2_10 n5_3 n10_8 prune eta2=0.5 factor=0.0550313854843489 factor2=0.06043810964594869 w0=0
X2_9_2_10m m2_9_2_10 p2_9_2_10 growth w0=0
R2_9_2_10p p2_9_2_10 n2_10 2647391.233933647
X2_9_2_10n q2_9_2_10 m2_9_2_10 growth w0=0
R2_9_2_10n q2_9_2_10 n2_10 2647391.233933647
X2_10_3_10p n2_10 m2_10_3_10 n5_3 n10_8 prune eta2=0.5 factor=0.05810696740807447 factor2=0.06836113812714643 w0=0
X2_10_3_10m m2_10_3_10 p2_10_3_10 growth w0=0
R2_10_3_10p p2_10_3_10 n3_10 2647391.233933647
X2_10_3_10n q2_10_3_10 m2_10_3_10 growth w0=0
R2_10_3_10n q2_10_3_10 n3_10 2647391.233933647
X2_10_2_11p n2_10 m2_10_2_11 n5_3 n10_8 prune eta2=0.5 factor=0.050235945792639576 factor2=0.058130165845768654 w0=0
X2_10_2_11m m2_10_2_11 p2_10_2_11 growth w0=0
R2_10_2_11p p2_10_2_11 n2_11 2647391.233933647
X2_10_2_11n q2_10_2_11 m2_10_2_11 growth w0=0
R2_10_2_11n q2_10_2_11 n2_11 2647391.233933647
X2_11_3_11p n2_11 m2_11_3_11 n5_3 n10_8 prune eta2=0.5 factor=0.05248572679779754 factor2=0.0650370919360487 w0=0
X2_11_3_11m m2_11_3_11 p2_11_3_11 growth w0=0
R2_11_3_11p p2_11_3_11 n3_11 2647391.233933647
X2_11_3_11n q2_11_3_11 m2_11_3_11 growth w0=0
R2_11_3_11n q2_11_3_11 n3_11 2647391.233933647
X2_11_2_12p n2_11 m2_11_2_12 n5_3 n10_8 prune eta2=0.5 factor=0.04608954240349232 factor2=0.055308222158221995 w0=0
X2_11_2_12m m2_11_2_12 p2_11_2_12 growth w0=0
R2_11_2_12p p2_11_2_12 n2_12 2647391.233933647
X2_11_2_12n q2_11_2_12 m2_11_2_12 growth w0=0
R2_11_2_12n q2_11_2_12 n2_12 2647391.233933647
X2_12_3_12p n2_12 m2_12_3_12 n5_3 n10_8 prune eta2=0.5 factor=0.04777466316213653 factor2=0.06111569205258361 w0=0
X2_12_3_12m m2_12_3_12 p2_12_3_12 growth w0=0
R2_12_3_12p p2_12_3_12 n3_12 2647391.233933647
X2_12_3_12n q2_12_3_12 m2_12_3_12 growth w0=0
R2_12_3_12n q2_12_3_12 n3_12 2647391.233933647
X2_12_2_13p n2_12 m2_12_2_13 n5_3 n10_8 prune eta2=0.5 factor=0.042502229440388985 factor2=0.052227794293251445 w0=0
X2_12_2_13m m2_12_2_13 p2_12_2_13 growth w0=0
R2_12_2_13p p2_12_2_13 n2_13 2647391.233933647
X2_12_2_13n q2_12_2_13 m2_12_2_13 growth w0=0
R2_12_2_13n q2_12_2_13 n2_13 2647391.233933647
X2_13_3_13p n2_13 m2_13_3_13 n5_3 n10_8 prune eta2=0.5 factor=0.043792008064457065 factor2=0.056996329751060046 w0=0
X2_13_3_13m m2_13_3_13 p2_13_3_13 growth w0=0
R2_13_3_13p p2_13_3_13 n3_13 2647391.233933647
X2_13_3_13n q2_13_3_13 m2_13_3_13 growth w0=0
R2_13_3_13n q2_13_3_13 n3_13 2647391.233933647
X2_13_2_14p n2_13 m2_13_2_14 n5_3 n10_8 prune eta2=0.5 factor=0.03938648747393874 factor2=0.049090909090909095 w0=0
X2_13_2_14m m2_13_2_14 p2_13_2_14 growth w0=0
R2_13_2_14p p2_13_2_14 n2_14 2647391.233933647
X2_13_2_14n q2_13_2_14 m2_13_2_14 growth w0=0
R2_13_2_14n q2_13_2_14 n2_14 2647391.233933647
X2_14_3_14p n2_14 m2_14_3_14 n5_3 n10_8 prune eta2=0.5 factor=0.04039296148910873 factor2=0.05295504832429591 w0=0
X2_14_3_14m m2_14_3_14 p2_14_3_14 growth w0=0
R2_14_3_14p p2_14_3_14 n3_14 2647391.233933647
X2_14_3_14n q2_14_3_14 m2_14_3_14 growth w0=0
R2_14_3_14n q2_14_3_14 n3_14 2647391.233933647
X2_14_2_15p n2_14 m2_14_2_15 n5_3 n10_8 prune eta2=0.5 factor=0.03666575360182205 factor2=0.04603538413957382 w0=0
X2_14_2_15m m2_14_2_15 p2_14_2_15 growth w0=0
R2_14_2_15p p2_14_2_15 n2_15 2647391.233933647
X2_14_2_15n q2_14_2_15 m2_14_2_15 growth w0=0
R2_14_2_15n q2_14_2_15 n2_15 2647391.233933647
X2_15_3_15p n2_15 m2_15_3_15 n5_3 n10_8 prune eta2=0.5 factor=0.037464760499335364 factor2=0.04915037704314248 w0=0
X2_15_3_15m m2_15_3_15 p2_15_3_15 growth w0=0
R2_15_3_15p p2_15_3_15 n3_15 2647391.233933647
X2_15_3_15n q2_15_3_15 m2_15_3_15 growth w0=0
R2_15_3_15n q2_15_3_15 n3_15 2647391.233933647
X3_1_4_1p n3_1 m3_1_4_1 n5_3 n10_8 prune eta2=0.5 factor=0.12360679774997897 factor2=0.05237944997294487 w0=0
X3_1_4_1m m3_1_4_1 p3_1_4_1 growth w0=0
R3_1_4_1p p3_1_4_1 n4_1 2647391.233933647
X3_1_4_1n q3_1_4_1 m3_1_4_1 growth w0=0
R3_1_4_1n q3_1_4_1 n4_1 2647391.233933647
X3_1_3_2p n3_1 m3_1_3_2 n5_3 n10_8 prune eta2=0.5 factor=0.09270509831248422 factor2=0.05295504832429591 w0=0
X3_1_3_2m m3_1_3_2 p3_1_3_2 growth w0=0
R3_1_3_2p p3_1_3_2 n3_2 2647391.233933647
X3_1_3_2n q3_1_3_2 m3_1_3_2 growth w0=0
R3_1_3_2n q3_1_3_2 n3_2 2647391.233933647
X3_2_4_2p n3_2 m3_2_4_2 n5_3 n10_8 prune eta2=0.5 factor=0.10355339059327377 factor2=0.057106019873885805 w0=0
X3_2_4_2m m3_2_4_2 p3_2_4_2 growth w0=0
R3_2_4_2p p3_2_4_2 n4_2 2647391.233933647
X3_2_4_2n q3_2_4_2 m3_2_4_2 growth w0=0
R3_2_4_2n q3_2_4_2 n4_2 2647391.233933647
X3_2_3_3p n3_2 m3_2_3_3 n5_3 n10_8 prune eta2=0.5 factor=0.08333333333333333 factor2=0.056996329751060046 w0=0
X3_2_3_3m m3_2_3_3 p3_2_3_3 growth w0=0
R3_2_3_3p p3_2_3_3 n3_3 2647391.233933647
X3_2_3_3n q3_2_3_3 m3_2_3_3 growth w0=0
R3_2_3_3n q3_2_3_3 n3_3 2647391.233933647
X3_3_4_3p n3_3 m3_3_4_3 n5_3 n10_8 prune eta2=0.5 factor=0.0 factor2=0.06233425249805272 w0=0
X3_3_4_3m m3_3_4_3 p3_3_4_3 growth w0=0
R3_3_4_3p p3_3_4_3 n4_3 2647391.233933647
X3_3_4_3n q3_3_4_3 m3_3_4_3 growth w0=0
R3_3_4_3n q3_3_4_3 n4_3 2647391.233933647
X3_3_3_4p n3_3 m3_3_3_4 n5_3 n10_8 prune eta2=0.5 factor=0.09270509831248422 factor2=0.06111569205258361 w0=0
X3_3_3_4m m3_3_3_4 p3_3_3_4 growth w0=0
R3_3_3_4p p3_3_3_4 n3_4 2647391.233933647
X3_3_3_4n q3_3_3_4 m3_3_3_4 growth w0=0
R3_3_3_4n q3_3_3_4 n3_4 2647391.233933647
X3_4_4_4p n3_4 m3_4_4_4 n5_3 n10_8 prune eta2=0.5 factor=0.10355339059327377 factor2=0.06791929637138439 w0=0
X3_4_4_4m m3_4_4_4 p3_4_4_4 growth w0=0
R3_4_4_4p p3_4_4_4 n4_4 2647391.233933647
X3_4_4_4n q3_4_4_4 m3_4_4_4 growth w0=0
R3_4_4_4n q3_4_4_4 n4_4 2647391.233933647
X3_4_3_5p n3_4 m3_4_3_5 n5_3 n10_8 prune eta2=0.5 factor=0.09795145311140303 factor2=0.0650370919360487 w0=0
X3_4_3_5m m3_4_3_5 p3_4_3_5 growth w0=0
R3_4_3_5p p3_4_3_5 n3_5 2647391.233933647
X3_4_3_5n q3_4_3_5 m3_4_3_5 growth w0=0
R3_4_3_5n q3_4_3_5 n3_5 2647391.233933647
X3_5_4_5p n3_5 m3_5_4_5 n5_3 n10_8 prune eta2=0.5 factor=0.12360679774997897 factor2=0.07351474761552217 w0=0
X3_5_4_5m m3_5_4_5 p3_5_4_5 growth w0=0
R3_5_4_5p p3_5_4_5 n4_5 2647391.233933647
X3_5_4_5n q3_5_4_5 m3_5_4_5 growth w0=0
R3_5_4_5n q3_5_4_5 n4_5 2647391.233933647
X3_5_3_6p n3_5 m3_5_3_6 n5_3 n10_8 prune eta2=0.5 factor=0.09186238471187141 factor2=0.06836113812714643 w0=0
X3_5_3_6m m3_5_3_6 p3_5_3_6 growth w0=0
R3_5_3_6p p3_5_3_6 n3_6 2647391.233933647
X3_5_3_6n q3_5_3_6 m3_5_3_6 growth w0=0
R3_5_3_6n q3_5_3_6 n3_6 2647391.233933647
X3_6_4_6p n3_6 m3_6_4_6 n5_3 n10_8 prune eta2=0.5 factor=0.10811388300841895 factor2=0.07850305921009322 w0=0
X3_6_4_6m m3_6_4_6 p3_6_4_6 growth w0=0
R3_6_4_6p p3_6_4_6 n4_6 2647391.233933647
X3_6_4_6n q3_6_4_6 m3_6_4_6 growth w0=0
R3_6_4_6n q3_6_4_6 n4_6 2647391.233933647
X3_6_3_7p n3_6 m3_6_3_7 n5_3 n10_8 prune eta2=0.5 factor=0.08223479893420056 factor2=0.07062262556659839 w0=0
X3_6_3_7m m3_6_3_7 p3_6_3_7 growth w0=0
R3_6_3_7p p3_6_3_7 n3_7 2647391.233933647
X3_6_3_7n q3_6_3_7 m3_6_3_7 growth w0=0
R3_6_3_7n q3_6_3_7 n3_7 2647391.233933647
X3_7_4_7p n3_7 m3_7_4_7 n5_3 n10_8 prune eta2=0.5 factor=0.09185604781228413 factor2=0.08204158738844725 w0=0
X3_7_4_7m m3_7_4_7 p3_7_4_7 growth w0=0
R3_7_4_7p p3_7_4_7 n4_7 2647391.233933647
X3_7_4_7n q3_7_4_7 m3_7_4_7 growth w0=0
R3_7_4_7n q3_7_4_7 n4_7 2647391.233933647
X3_7_3_8p n3_7 m3_7_3_8 n5_3 n10_8 prune eta2=0.5 factor=0.07290606514324606 factor2=0.07142857142857142 w0=0
X3_7_3_8m m3_7_3_8 p3_7_3_8 growth w0=0
R3_7_3_8p p3_7_3_8 n3_8 2647391.233933647
X3_7_3_8n q3_7_3_8 m3_7_3_8 growth w0=0
R3_7_3_8n q3_7_3_8 n3_8 2647391.233933647
X3_8_4_8p n3_8 m3_8_4_8 n5_3 n10_8 prune eta2=0.5 factor=0.07882729833832279 factor2=0.08333333333333334 w0=0
X3_8_4_8m m3_8_4_8 p3_8_4_8 growth w0=0
R3_8_4_8p p3_8_4_8 n4_8 2647391.233933647
X3_8_4_8n q3_8_4_8 m3_8_4_8 growth w0=0
R3_8_4_8n q3_8_4_8 n4_8 2647391.233933647
X3_8_3_9p n3_8 m3_8_3_9 n5_3 n10_8 prune eta2=0.5 factor=0.06485035326051179 factor2=0.07062262556659839 w0=0
X3_8_3_9m m3_8_3_9 p3_8_3_9 growth w0=0
R3_8_3_9p p3_8_3_9 n3_9 2647391.233933647
X3_8_3_9n q3_8_3_9 m3_8_3_9 growth w0=0
R3_8_3_9n q3_8_3_9 n3_9 2647391.233933647
X3_9_4_9p n3_9 m3_9_4_9 n5_3 n10_8 prune eta2=0.5 factor=0.06868598013916513 factor2=0.08204158738844725 w0=0
X3_9_4_9m m3_9_4_9 p3_9_4_9 growth w0=0
R3_9_4_9p p3_9_4_9 n4_9 2647391.233933647
X3_9_4_9n q3_9_4_9 m3_9_4_9 growth w0=0
R3_9_4_9n q3_9_4_9 n4_9 2647391.233933647
X3_9_3_10p n3_9 m3_9_3_10 n5_3 n10_8 prune eta2=0.5 factor=0.05810696740807447 factor2=0.06836113812714643 w0=0
X3_9_3_10m m3_9_3_10 p3_9_3_10 growth w0=0
R3_9_3_10p p3_9_3_10 n3_10 2647391.233933647
X3_9_3_10n q3_9_3_10 m3_9_3_10 growth w0=0
R3_9_3_10n q3_9_3_10 n3_10 2647391.233933647
X3_10_4_10p n3_10 m3_10_4_10 n5_3 n10_8 prune eta2=0.5 factor=0.06071067811865475 factor2=0.07850305921009322 w0=0
X3_10_4_10m m3_10_4_10 p3_10_4_10 growth w0=0
R3_10_4_10p p3_10_4_10 n4_10 2647391.233933647
X3_10_4_10n q3_10_4_10 m3_10_4_10 growth w0=0
R3_10_4_10n q3_10_4_10 n4_10 2647391.233933647
X3_10_3_11p n3_10 m3_10_3_11 n5_3 n10_8 prune eta2=0.5 factor=0.05248572679779754 factor2=0.0650370919360487 w0=0
X3_10_3_11m m3_10_3_11 p3_10_3_11 growth w0=0
R3_10_3_11p p3_10_3_11 n3_11 2647391.233933647
X3_10_3_11n q3_10_3_11 m3_10_3_11 growth w0=0
R3_10_3_11n q3_10_3_11 n3_11 2647391.233933647
X3_11_4_11p n3_11 m3_11_4_11 n5_3 n10_8 prune eta2=0.5 factor=0.05432505960229654 factor2=0.07351474761552217 w0=0
X3_11_4_11m m3_11_4_11 p3_11_4_11 growth w0=0
R3_11_4_11p p3_11_4_11 n4_11 2647391.233933647
X3_11_4_11n q3_11_4_11 m3_11_4_11 growth w0=0
R3_11_4_11n q3_11_4_11 n4_11 2647391.233933647
X3_11_3_12p n3_11 m3_11_3_12 n5_3 n10_8 prune eta2=0.5 factor=0.04777466316213653 factor2=0.06111569205258361 w0=0
X3_11_3_12m m3_11_3_12 p3_11_3_12 growth w0=0
R3_11_3_12p p3_11_3_12 n3_12 2647391.233933647
X3_11_3_12n q3_11_3_12 m3_11_3_12 growth w0=0
R3_11_3_12n q3_11_3_12 n3_12 2647391.233933647
X3_12_4_12p n3_12 m3_12_4_12 n5_3 n10_8 prune eta2=0.5 factor=0.04911820206181351 factor2=0.06791929637138439 w0=0
X3_12_4_12m m3_12_4_12 p3_12_4_12 growth w0=0
R3_12_4_12p p3_12_4_12 n4_12 2647391.233933647
X3_12_4_12n q3_12_4_12 m3_12_4_12 growth w0=0
R3_12_4_12n q3_12_4_12 n4_12 2647391.233933647
X3_12_3_13p n3_12 m3_12_3_13 n5_3 n10_8 prune eta2=0.5 factor=0.043792008064457065 factor2=0.056996329751060046 w0=0
X3_12_3_13m m3_12_3_13 p3_12_3_13 growth w0=0
R3_12_3_13p p3_12_3_13 n3_13 2647391.233933647
X3_12_3_13n q3_12_3_13 m3_12_3_13 growth w0=0
R3_12_3_13n q3_12_3_13 n3_13 2647391.233933647
X3_13_4_13p n3_13 m3_13_4_13 n5_3 n10_8 prune eta2=0.5 factor=0.04480136446099451 factor2=0.06233425249805272 w0=0
X3_13_4_13m m3_13_4_13 p3_13_4_13 growth w0=0
R3_13_4_13p p3_13_4_13 n4_13 2647391.233933647
X3_13_4_13n q3_13_4_13 m3_13_4_13 growth w0=0
R3_13_4_13n q3_13_4_13 n4_13 2647391.233933647
X3_13_3_14p n3_13 m3_13_3_14 n5_3 n10_8 prune eta2=0.5 factor=0.04039296148910873 factor2=0.05295504832429591 w0=0
X3_13_3_14m m3_13_3_14 p3_13_3_14 growth w0=0
R3_13_3_14p p3_13_3_14 n3_14 2647391.233933647
X3_13_3_14n q3_13_3_14 m3_13_3_14 growth w0=0
R3_13_3_14n q3_13_3_14 n3_14 2647391.233933647
X3_14_4_14p n3_14 m3_14_4_14 n5_3 n10_8 prune eta2=0.5 factor=0.041169512365521556 factor2=0.057106019873885805 w0=0
X3_14_4_14m m3_14_4_14 p3_14_4_14 growth w0=0
R3_14_4_14p p3_14_4_14 n4_14 6006.050391399449
X3_14_4_14n q3_14_4_14 m3_14_4_14 growth w0=0
R3_14_4_14n q3_14_4_14 n4_14 3004981.5674761934
X3_14_3_15p n3_15 m3_14_3_15 n5_3 n10_8 prune eta2=0.5 factor=0.04039296148910873 factor2=0.05295504832429591 w0=0
X3_14_3_15m m3_14_3_15 p3_14_3_15 growth w0=0
R3_14_3_15p p3_14_3_15 n3_14 6006.050391399449
X3_14_3_15n q3_14_3_15 m3_14_3_15 growth w0=0
R3_14_3_15n q3_14_3_15 n3_14 3004981.5674761934
X3_15_4_15p n3_15 m3_15_4_15 n5_3 n10_8 prune eta2=0.5 factor=0.038074464064801014 factor2=0.05237944997294487 w0=0
X3_15_4_15m m3_15_4_15 p3_15_4_15 growth w0=0
R3_15_4_15p p3_15_4_15 n4_15 2647391.233933647
X3_15_4_15n q3_15_4_15 m3_15_4_15 growth w0=0
R3_15_4_15n q3_15_4_15 n4_15 2647391.233933647
X4_1_5_1p n4_1 m4_1_5_1 n5_3 n10_8 prune eta2=0.5 factor=0.16666666666666666 factor2=0.055589012967083254 w0=0
X4_1_5_1m m4_1_5_1 p4_1_5_1 growth w0=0
R4_1_5_1p p4_1_5_1 n5_1 2647391.233933647
X4_1_5_1n q4_1_5_1 m4_1_5_1 growth w0=0
R4_1_5_1n q4_1_5_1 n5_1 2647391.233933647
X4_1_4_2p n4_1 m4_1_4_2 n5_3 n10_8 prune eta2=0.5 factor=0.10355339059327377 factor2=0.057106019873885805 w0=0
X4_1_4_2m m4_1_4_2 p4_1_4_2 growth w0=0
R4_1_4_2p p4_1_4_2 n4_2 2647391.233933647
X4_1_4_2n q4_1_4_2 m4_1_4_2 growth w0=0
R4_1_4_2n q4_1_4_2 n4_2 2647391.233933647
X4_2_5_2p n4_2 m4_2_5_2 n5_3 n10_8 prune eta2=0.5 factor=0.25 factor2=0.061403890520469843 w0=0
X4_2_5_2m m4_2_5_2 p4_2_5_2 growth w0=0
R4_2_5_2p p4_2_5_2 n5_2 2647391.233933647
X4_2_5_2n q4_2_5_2 m4_2_5_2 growth w0=0
R4_2_5_2n q4_2_5_2 n5_2 2647391.233933647
X4_2_4_3p n4_2 m4_2_4_3 n5_3 n10_8 prune eta2=0.5 factor=0.0 factor2=0.06233425249805272 w0=0
X4_2_4_3m m4_2_4_3 p4_2_4_3 growth w0=0
R4_2_4_3p p4_2_4_3 n4_3 2647391.233933647
X4_2_4_3n q4_2_4_3 m4_2_4_3 growth w0=0
R4_2_4_3n q4_2_4_3 n4_3 2647391.233933647
X4_3_5_3p n4_3 m4_3_5_3 n5_3 n10_8 prune eta2=0.5 factor=0.5 factor2=0.06814463870461249 w0=0
X4_3_5_3m m4_3_5_3 p4_3_5_3 growth w0=0
R4_3_5_3p p4_3_5_3 n5_3 2647391.233933647
X4_3_5_3n q4_3_5_3 m4_3_5_3 growth w0=0
R4_3_5_3n q4_3_5_3 n5_3 2647391.233933647
X4_3_4_4p n4_3 m4_3_4_4 n5_3 n10_8 prune eta2=0.5 factor=0.10355339059327377 factor2=0.06791929637138439 w0=0
X4_3_4_4m m4_3_4_4 p4_3_4_4 growth w0=0
R4_3_4_4p p4_3_4_4 n4_4 2647391.233933647
X4_3_4_4n q4_3_4_4 m4_3_4_4 growth w0=0
R4_3_4_4n q4_3_4_4 n4_4 2647391.233933647
X4_4_5_4p n4_4 m4_4_5_4 n5_3 n10_8 prune eta2=0.5 factor=0.25 factor2=0.07577552284204606 w0=0
X4_4_5_4m m4_4_5_4 p4_4_5_4 growth w0=0
R4_4_5_4p p4_4_5_4 n5_4 2647391.233933647
X4_4_5_4n q4_4_5_4 m4_4_5_4 growth w0=0
R4_4_5_4n q4_4_5_4 n5_4 2647391.233933647
X4_4_4_5p n4_4 m4_4_4_5 n5_3 n10_8 prune eta2=0.5 factor=0.12360679774997897 factor2=0.07351474761552217 w0=0
X4_4_4_5m m4_4_4_5 p4_4_4_5 growth w0=0
R4_4_4_5p p4_4_4_5 n4_5 2647391.233933647
X4_4_4_5n q4_4_4_5 m4_4_4_5 growth w0=0
R4_4_4_5n q4_4_4_5 n4_5 2647391.233933647
X4_5_5_5p n4_5 m4_5_5_5 n5_3 n10_8 prune eta2=0.5 factor=0.16666666666666666 factor2=0.08396039389437018 w0=0
X4_5_5_5m m4_5_5_5 p4_5_5_5 growth w0=0
R4_5_5_5p p4_5_5_5 n5_5 2647391.233933647
X4_5_5_5n q4_5_5_5 m4_5_5_5 growth w0=0
R4_5_5_5n q4_5_5_5 n5_5 2647391.233933647
X4_5_4_6p n4_5 m4_5_4_6 n5_3 n10_8 prune eta2=0.5 factor=0.10811388300841895 factor2=0.07850305921009322 w0=0
X4_5_4_6m m4_5_4_6 p4_5_4_6 growth w0=0
R4_5_4_6p p4_5_4_6 n4_6 2647391.233933647
X4_5_4_6n q4_5_4_6 m4_5_4_6 growth w0=0
R4_5_4_6n q4_5_4_6 n4_6 2647391.233933647
X4_6_5_6p n4_6 m4_6_5_6 n5_3 n10_8 prune eta2=0.5 factor=0.125 factor2=0.09180763758779135 w0=0
X4_6_5_6m m4_6_5_6 p4_6_5_6 growth w0=0
R4_6_5_6p p4_6_5_6 n5_6 2647391.233933647
X4_6_5_6n q4_6_5_6 m4_6_5_6 growth w0=0
R4_6_5_6n q4_6_5_6 n5_6 2647391.233933647
X4_6_4_7p n4_6 m4_6_4_7 n5_3 n10_8 prune eta2=0.5 factor=0.09185604781228413 factor2=0.08204158738844725 w0=0
X4_6_4_7m m4_6_4_7 p4_6_4_7 growth w0=0
R4_6_4_7p p4_6_4_7 n4_7 2647391.233933647
X4_6_4_7n q4_6_4_7 m4_6_4_7 growth w0=0
R4_6_4_7n q4_6_4_7 n4_7 2647391.233933647
X4_7_5_7p n4_7 m4_7_5_7 n5_3 n10_8 prune eta2=0.5 factor=0.1 factor2=0.09774584993952026 w0=0
X4_7_5_7m m4_7_5_7 p4_7_5_7 growth w0=0
R4_7_5_7p p4_7_5_7 n5_7 2647391.233933647
X4_7_5_7n q4_7_5_7 m4_7_5_7 growth w0=0
R4_7_5_7n q4_7_5_7 n5_7 2647391.233933647
X4_7_4_8p n4_7 m4_7_4_8 n5_3 n10_8 prune eta2=0.5 factor=0.07882729833832279 factor2=0.08333333333333334 w0=0
X4_7_4_8m m4_7_4_8 p4_7_4_8 growth w0=0
R4_7_4_8p p4_7_4_8 n4_8 2647391.233933647
X4_7_4_8n q4_7_4_8 m4_7_4_8 growth w0=0
R4_7_4_8n q4_7_4_8 n4_8 2647391.233933647
X4_8_5_8p n4_8 m4_8_5_8 n5_3 n10_8 prune eta2=0.5 factor=0.08333333333333333 factor2=0.09999999999999999 w0=0
X4_8_5_8m m4_8_5_8 p4_8_5_8 growth w0=0
R4_8_5_8p p4_8_5_8 n5_8 2647391.233933647
X4_8_5_8n q4_8_5_8 m4_8_5_8 growth w0=0
R4_8_5_8n q4_8_5_8 n5_8 2647391.233933647
X4_8_4_9p n4_8 m4_8_4_9 n5_3 n10_8 prune eta2=0.5 factor=0.06868598013916513 factor2=0.08204158738844725 w0=0
X4_8_4_9m m4_8_4_9 p4_8_4_9 growth w0=0
R4_8_4_9p p4_8_4_9 n4_9 2647391.233933647
X4_8_4_9n q4_8_4_9 m4_8_4_9 growth w0=0
R4_8_4_9n q4_8_4_9 n4_9 2647391.233933647
X4_9_5_9p n4_9 m4_9_5_9 n5_3 n10_8 prune eta2=0.5 factor=0.07142857142857142 factor2=0.09774584993952026 w0=0
X4_9_5_9m m4_9_5_9 p4_9_5_9 growth w0=0
R4_9_5_9p p4_9_5_9 n5_9 2647391.233933647
X4_9_5_9n q4_9_5_9 m4_9_5_9 growth w0=0
R4_9_5_9n q4_9_5_9 n5_9 2647391.233933647
X4_9_4_10p n4_9 m4_9_4_10 n5_3 n10_8 prune eta2=0.5 factor=0.06071067811865475 factor2=0.07850305921009322 w0=0
X4_9_4_10m m4_9_4_10 p4_9_4_10 growth w0=0
R4_9_4_10p p4_9_4_10 n4_10 2647391.233933647
X4_9_4_10n q4_9_4_10 m4_9_4_10 growth w0=0
R4_9_4_10n q4_9_4_10 n4_10 2647391.233933647
X4_10_5_10p n4_10 m4_10_5_10 n5_3 n10_8 prune eta2=0.5 factor=0.0625 factor2=0.09180763758779135 w0=0
X4_10_5_10m m4_10_5_10 p4_10_5_10 growth w0=0
R4_10_5_10p p4_10_5_10 n5_10 2647391.233933647
X4_10_5_10n q4_10_5_10 m4_10_5_10 growth w0=0
R4_10_5_10n q4_10_5_10 n5_10 2647391.233933647
X4_10_4_11p n4_10 m4_10_4_11 n5_3 n10_8 prune eta2=0.5 factor=0.05432505960229654 factor2=0.07351474761552217 w0=0
X4_10_4_11m m4_10_4_11 p4_10_4_11 growth w0=0
R4_10_4_11p p4_10_4_11 n4_11 2647391.233933647
X4_10_4_11n q4_10_4_11 m4_10_4_11 growth w0=0
R4_10_4_11n q4_10_4_11 n4_11 2647391.233933647
X4_11_5_11p n4_11 m4_11_5_11 n5_3 n10_8 prune eta2=0.5 factor=0.05555555555555555 factor2=0.08396039389437018 w0=0
X4_11_5_11m m4_11_5_11 p4_11_5_11 growth w0=0
R4_11_5_11p p4_11_5_11 n5_11 2647391.233933647
X4_11_5_11n q4_11_5_11 m4_11_5_11 growth w0=0
R4_11_5_11n q4_11_5_11 n5_11 2647391.233933647
X4_11_4_12p n4_11 m4_11_4_12 n5_3 n10_8 prune eta2=0.5 factor=0.04911820206181351 factor2=0.06791929637138439 w0=0
X4_11_4_12m m4_11_4_12 p4_11_4_12 growth w0=0
R4_11_4_12p p4_11_4_12 n4_12 2647391.233933647
X4_11_4_12n q4_11_4_12 m4_11_4_12 growth w0=0
R4_11_4_12n q4_11_4_12 n4_12 2647391.233933647
X4_12_5_12p n4_12 m4_12_5_12 n5_3 n10_8 prune eta2=0.5 factor=0.05 factor2=0.07577552284204606 w0=0
X4_12_5_12m m4_12_5_12 p4_12_5_12 growth w0=0
R4_12_5_12p p4_12_5_12 n5_12 2647391.233933647
X4_12_5_12n q4_12_5_12 m4_12_5_12 growth w0=0
R4_12_5_12n q4_12_5_12 n5_12 2647391.233933647
X4_12_4_13p n4_12 m4_12_4_13 n5_3 n10_8 prune eta2=0.5 factor=0.04480136446099451 factor2=0.06233425249805272 w0=0
X4_12_4_13m m4_12_4_13 p4_12_4_13 growth w0=0
R4_12_4_13p p4_12_4_13 n4_13 2647391.233933647
X4_12_4_13n q4_12_4_13 m4_12_4_13 growth w0=0
R4_12_4_13n q4_12_4_13 n4_13 2647391.233933647
X4_13_5_13p n4_13 m4_13_5_13 n5_3 n10_8 prune eta2=0.5 factor=0.045454545454545456 factor2=0.06814463870461249 w0=0
X4_13_5_13m m4_13_5_13 p4_13_5_13 growth w0=0
R4_13_5_13p p4_13_5_13 n5_13 6006.050391399449
X4_13_5_13n q4_13_5_13 m4_13_5_13 growth w0=0
R4_13_5_13n q4_13_5_13 n5_13 3004981.5674761934
X4_13_4_14p n4_14 m4_13_4_14 n5_3 n10_8 prune eta2=0.5 factor=0.04480136446099451 factor2=0.06233425249805272 w0=0
X4_13_4_14m m4_13_4_14 p4_13_4_14 growth w0=0
R4_13_4_14p p4_13_4_14 n4_13 6006.050391399449
X4_13_4_14n q4_13_4_14 m4_13_4_14 growth w0=0
R4_13_4_14n q4_13_4_14 n4_13 3004981.5674761934
X4_14_5_14p n4_14 m4_14_5_14 n5_3 n10_8 prune eta2=0.5 factor=0.041666666666666664 factor2=0.061403890520469843 w0=0
X4_14_5_14m m4_14_5_14 p4_14_5_14 growth w0=0
R4_14_5_14p p4_14_5_14 n5_14 2647391.233933647
X4_14_5_14n q4_14_5_14 m4_14_5_14 growth w0=0
R4_14_5_14n q4_14_5_14 n5_14 2647391.233933647
X4_14_4_15p n4_14 m4_14_4_15 n5_3 n10_8 prune eta2=0.5 factor=0.038074464064801014 factor2=0.05237944997294487 w0=0
X4_14_4_15m m4_14_4_15 p4_14_4_15 growth w0=0
R4_14_4_15p p4_14_4_15 n4_15 2647391.233933647
X4_14_4_15n q4_14_4_15 m4_14_4_15 growth w0=0
R4_14_4_15n q4_14_4_15 n4_15 2647391.233933647
X4_15_5_15p n4_15 m4_15_5_15 n5_3 n10_8 prune eta2=0.5 factor=0.038461538461538464 factor2=0.055589012967083254 w0=0
X4_15_5_15m m4_15_5_15 p4_15_5_15 growth w0=0
R4_15_5_15p p4_15_5_15 n5_15 2647391.233933647
X4_15_5_15n q4_15_5_15 m4_15_5_15 growth w0=0
R4_15_5_15n q4_15_5_15 n5_15 2647391.233933647
X5_1_6_1p n5_1 m5_1_6_1 n5_3 n10_8 prune eta2=0.5 factor=0.18541019662496844 factor2=0.05856920488372595 w0=0
X5_1_6_1m m5_1_6_1 p5_1_6_1 growth w0=0
R5_1_6_1p p5_1_6_1 n6_1 2647391.233933647
X5_1_6_1n q5_1_6_1 m5_1_6_1 growth w0=0
R5_1_6_1n q5_1_6_1 n6_1 2647391.233933647
X5_1_5_2p n5_1 m5_1_5_2 n5_3 n10_8 prune eta2=0.5 factor=0.25 factor2=0.061403890520469843 w0=0
X5_1_5_2m m5_1_5_2 p5_1_5_2 growth w0=0
R5_1_5_2p p5_1_5_2 n5_2 2647391.233933647
X5_1_5_2n q5_1_5_2 m5_1_5_2 growth w0=0
R5_1_5_2n q5_1_5_2 n5_2 2647391.233933647
X5_2_6_2p n5_2 m5_2_6_2 n5_3 n10_8 prune eta2=0.5 factor=0.3106601717798213 factor2=0.06557725166892284 w0=0
X5_2_6_2m m5_2_6_2 p5_2_6_2 growth w0=0
R5_2_6_2p p5_2_6_2 n6_2 2647391.233933647
X5_2_6_2n q5_2_6_2 m5_2_6_2 growth w0=0
R5_2_6_2n q5_2_6_2 n6_2 2647391.233933647
X5_2_5_3p n5_2 m5_2_5_3 n5_3 n10_8 prune eta2=0.5 factor=0.5 factor2=0.06814463870461249 w0=0
X5_2_5_3m m5_2_5_3 p5_2_5_3 growth w0=0
R5_2_5_3p p5_2_5_3 n5_3 2647391.233933647
X5_2_5_3n q5_2_5_3 m5_2_5_3 growth w0=0
R5_2_5_3n q5_2_5_3 n5_3 2647391.233933647
X5_4_6_4p n5_4 m5_4_6_4 n5_3 n10_8 prune eta2=0.5 factor=0.3106601717798213 factor2=0.08449937146256334 w0=0
X5_4_6_4m m5_4_6_4 p5_4_6_4 growth w0=0
R5_4_6_4p p5_4_6_4 n6_4 2647391.233933647
X5_4_6_4n q5_4_6_4 m5_4_6_4 growth w0=0
R5_4_6_4n q5_4_6_4 n6_4 2647391.233933647
X5_4_5_5p n5_5 m5_4_5_5 n5_3 n10_8 prune eta2=0.5 factor=0.25 factor2=0.07577552284204606 w0=0
X5_4_5_5m m5_4_5_5 p5_4_5_5 growth w0=0
R5_4_5_5p p5_4_5_5 n5_4 6006.050391399449
X5_4_5_5n q5_4_5_5 m5_4_5_5 growth w0=0
R5_4_5_5n q5_4_5_5 n5_4 3004981.5674761934
X5_5_6_5p n5_5 m5_5_6_5 n5_3 n10_8 prune eta2=0.5 factor=0.18541019662496844 factor2=0.09666666666666666 w0=0
X5_5_6_5m m5_5_6_5 p5_5_6_5 growth w0=0
R5_5_6_5p p5_5_6_5 n6_5 2647391.233933647
X5_5_6_5n q5_5_6_5 m5_5_6_5 growth w0=0
R5_5_6_5n q5_5_6_5 n6_5 2647391.233933647
X5_5_5_6p n5_6 m5_5_5_6 n5_3 n10_8 prune eta2=0.5 factor=0.16666666666666666 factor2=0.08396039389437018 w0=0
X5_5_5_6m m5_5_5_6 p5_5_5_6 growth w0=0
R5_5_5_6p p5_5_5_6 n5_5 6006.050391399449
X5_5_5_6n q5_5_5_6 m5_5_5_6 growth w0=0
R5_5_5_6n q5_5_5_6 n5_5 3004981.5674761934
X5_6_6_6p n5_6 m5_6_6_6 n5_3 n10_8 prune eta2=0.5 factor=0.13213919034362318 factor2=0.10964639857893407 w0=0
X5_6_6_6m m5_6_6_6 p5_6_6_6 growth w0=0
R5_6_6_6p p5_6_6_6 n6_6 2647391.233933647
X5_6_6_6n q5_6_6_6 m5_6_6_6 growth w0=0
R5_6_6_6n q5_6_6_6 n6_6 2647391.233933647
X5_6_5_7p n5_7 m5_6_5_7 n5_3 n10_8 prune eta2=0.5 factor=0.125 factor2=0.09180763758779135 w0=0
X5_6_5_7m m5_6_5_7 p5_6_5_7 growth w0=0
R5_6_5_7p p5_6_5_7 n5_6 6006.050391399449
X5_6_5_7n q5_6_5_7 m5_6_5_7 growth w0=0
R5_6_5_7n q5_6_5_7 n5_6 3004981.5674761934
X5_7_6_7p n5_7 m5_7_6_7 n5_3 n10_8 prune eta2=0.5 factor=0.10333805378881965 factor2=0.12056106275362292 w0=0
X5_7_6_7m m5_7_6_7 p5_7_6_7 growth w0=0
R5_7_6_7p p5_7_6_7 n6_7 2647391.233933647
X5_7_6_7n q5_7_6_7 m5_7_6_7 growth w0=0
R5_7_6_7n q5_7_6_7 n6_7 2647391.233933647
X5_7_5_8p n5_8 m5_7_5_8 n5_3 n10_8 prune eta2=0.5 factor=0.1 factor2=0.09774584993952026 w0=0
X5_7_5_8m m5_7_5_8 p5_7_5_8 growth w0=0
R5_7_5_8p p5_7_5_8 n5_7 6006.050391399449
X5_7_5_8n q5_7_5_8 m5_7_5_8 growth w0=0
R5_7_5_8n q5_7_5_8 n5_7 3004981.5674761934
X5_8_6_8p n5_8 m5_8_6_8 n5_3 n10_8 prune eta2=0.5 factor=0.08513348220538862 factor2=0.125 w0=0
X5_8_6_8m m5_8_6_8 p5_8_6_8 growth w0=0
R5_8_6_8p p5_8_6_8 n6_8 6006.050391399449
X5_8_6_8n q5_8_6_8 m5_8_6_8 growth w0=0
R5_8_6_8n q5_8_6_8 n6_8 3004981.5674761934
X5_8_5_9p n5_9 m5_8_5_9 n5_3 n10_8 prune eta2=0.5 factor=0.08333333333333333 factor2=0.09999999999999999 w0=0
X5_8_5_9m m5_8_5_9 p5_8_5_9 growth w0=0
R5_8_5_9p p5_8_5_9 n5_8 6006.050391399449
X5_8_5_9n q5_8_5_9 m5_8_5_9 growth w0=0
R5_8_5_9n q5_8_5_9 n5_8 3004981.5674761934
X5_9_6_9p n5_9 m5_9_6_9 n5_3 n10_8 prune eta2=0.5 factor=0.07250186792467431 factor2=0.12056106275362292 w0=0
X5_9_6_9m m5_9_6_9 p5_9_6_9 growth w0=0
R5_9_6_9p p5_9_6_9 n6_9 2647391.233933647
X5_9_6_9n q5_9_6_9 m5_9_6_9 growth w0=0
R5_9_6_9n q5_9_6_9 n6_9 2647391.233933647
X5_9_5_10p n5_10 m5_9_5_10 n5_3 n10_8 prune eta2=0.5 factor=0.07142857142857142 factor2=0.09774584993952026 w0=0
X5_9_5_10m m5_9_5_10 p5_9_5_10 growth w0=0
R5_9_5_10p p5_9_5_10 n5_9 6006.050391399449
X5_9_5_10n q5_9_5_10 m5_9_5_10 growth w0=0
R5_9_5_10n q5_9_5_10 n5_9 3004981.5674761934
X5_10_6_10p n5_10 m5_10_6_10 n5_3 n10_8 prune eta2=0.5 factor=0.06318866498064066 factor2=0.10964639857893407 w0=0
X5_10_6_10m m5_10_6_10 p5_10_6_10 growth w0=0
R5_10_6_10p p5_10_6_10 n6_10 2647391.233933647
X5_10_6_10n q5_10_6_10 m5_10_6_10 growth w0=0
R5_10_6_10n q5_10_6_10 n6_10 2647391.233933647
X5_10_5_11p n5_11 m5_10_5_11 n5_3 n10_8 prune eta2=0.5 factor=0.0625 factor2=0.09180763758779135 w0=0
X5_10_5_11m m5_10_5_11 p5_10_5_11 growth w0=0
R5_10_5_11p p5_10_5_11 n5_10 6006.050391399449
X5_10_5_11n q5_10_5_11 m5_10_5_11 growth w0=0
R5_10_5_11n q5_10_5_11 n5_10 3004981.5674761934
X5_11_6_11p n5_11 m5_11_6_11 n5_3 n10_8 prune eta2=0.5 factor=0.0560227177148683 factor2=0.09666666666666666 w0=0
X5_11_6_11m m5_11_6_11 p5_11_6_11 growth w0=0
R5_11_6_11p p5_11_6_11 n6_11 2647391.233933647
X5_11_6_11n q5_11_6_11 m5_11_6_11 growth w0=0
R5_11_6_11n q5_11_6_11 n6_11 2647391.233933647
X5_11_5_12p n5_12 m5_11_5_12 n5_3 n10_8 prune eta2=0.5 factor=0.05555555555555555 factor2=0.08396039389437018 w0=0
X5_11_5_12m m5_11_5_12 p5_11_5_12 growth w0=0
R5_11_5_12p p5_11_5_12 n5_11 6006.050391399449
X5_11_5_12n q5_11_5_12 m5_11_5_12 growth w0=0
R5_11_5_12n q5_11_5_12 n5_11 3004981.5674761934
X5_12_6_12p n5_12 m5_12_6_12 n5_3 n10_8 prune eta2=0.5 factor=0.05033099717445089 factor2=0.08449937146256334 w0=0
X5_12_6_12m m5_12_6_12 p5_12_6_12 growth w0=0
R5_12_6_12p p5_12_6_12 n6_12 2647391.233933647
X5_12_6_12n q5_12_6_12 m5_12_6_12 growth w0=0
R5_12_6_12n q5_12_6_12 n6_12 2647391.233933647
X5_12_5_13p n5_13 m5_12_5_13 n5_3 n10_8 prune eta2=0.5 factor=0.05 factor2=0.07577552284204606 w0=0
X5_12_5_13m m5_12_5_13 p5_12_5_13 growth w0=0
R5_12_5_13p p5_12_5_13 n5_12 6006.050391399449
X5_12_5_13n q5_12_5_13 m5_12_5_13 growth w0=0
R5_12_5_13n q5_12_5_13 n5_12 3004981.5674761934
X5_13_6_13p n5_13 m5_13_6_13 n5_3 n10_8 prune eta2=0.5 factor=0.0456973917502144 factor2=0.07412822886721897 w0=0
X5_13_6_13m m5_13_6_13 p5_13_6_13 growth w0=0
R5_13_6_13p p5_13_6_13 n6_13 2647391.233933647
X5_13_6_13n q5_13_6_13 m5_13_6_13 growth w0=0
R5_13_6_13n q5_13_6_13 n6_13 2647391.233933647
X5_13_5_14p n5_13 m5_13_5_14 n5_3 n10_8 prune eta2=0.5 factor=0.041666666666666664 factor2=0.061403890520469843 w0=0
X5_13_5_14m m5_13_5_14 p5_13_5_14 growth w0=0
R5_13_5_14p p5_13_5_14 n5_14 2647391.233933647
X5_13_5_14n q5_13_5_14 m5_13_5_14 growth w0=0
R5_13_5_14n q5_13_5_14 n5_14 2647391.233933647
X5_14_6_14p n5_14 m5_14_6_14 n5_3 n10_8 prune eta2=0.5 factor=0.04185000017321613 factor2=0.06557725166892284 w0=0
X5_14_6_14m m5_14_6_14 p5_14_6_14 growth w0=0
R5_14_6_14p p5_14_6_14 n6_14 2647391.233933647
X5_14_6_14n q5_14_6_14 m5_14_6_14 growth w0=0
R5_14_6_14n q5_14_6_14 n6_14 2647391.233933647
X5_14_5_15p n5_14 m5_14_5_15 n5_3 n10_8 prune eta2=0.5 factor=0.038461538461538464 factor2=0.055589012967083254 w0=0
X5_14_5_15m m5_14_5_15 p5_14_5_15 growth w0=0
R5_14_5_15p p5_14_5_15 n5_15 2647391.233933647
X5_14_5_15n q5_14_5_15 m5_14_5_15 growth w0=0
R5_14_5_15n q5_14_5_15 n5_15 2647391.233933647
X5_15_6_15p n5_15 m5_15_6_15 n5_3 n10_8 prune eta2=0.5 factor=0.038603276065701034 factor2=0.05856920488372595 w0=0
X5_15_6_15m m5_15_6_15 p5_15_6_15 growth w0=0
R5_15_6_15p p5_15_6_15 n6_15 2647391.233933647
X5_15_6_15n q5_15_6_15 m5_15_6_15 growth w0=0
R5_15_6_15n q5_15_6_15 n6_15 2647391.233933647
X6_1_7_1p n6_1 m6_1_7_1 n5_3 n10_8 prune eta2=0.5 factor=0.1632524218523384 factor2=0.06103480935536878 w0=0
X6_1_7_1m m6_1_7_1 p6_1_7_1 growth w0=0
R6_1_7_1p p6_1_7_1 n7_1 2647391.233933647
X6_1_7_1n q6_1_7_1 m6_1_7_1 growth w0=0
R6_1_7_1n q6_1_7_1 n7_1 2647391.233933647
X6_1_6_2p n6_1 m6_1_6_2 n5_3 n10_8 prune eta2=0.5 factor=0.3106601717798213 factor2=0.06557725166892284 w0=0
X6_1_6_2m m6_1_6_2 p6_1_6_2 growth w0=0
R6_1_6_2p p6_1_6_2 n6_2 2647391.233933647
X6_1_6_2n q6_1_6_2 m6_1_6_2 growth w0=0
R6_1_6_2n q6_1_6_2 n6_2 2647391.233933647
X6_2_7_2p n6_2 m6_2_7_2 n5_3 n10_8 prune eta2=0.5 factor=0.21631189606246318 factor2=0.06919035069696204 w0=0
X6_2_7_2m m6_2_7_2 p6_2_7_2 growth w0=0
R6_2_7_2p p6_2_7_2 n7_2 2647391.233933647
X6_2_7_2n q6_2_7_2 m6_2_7_2 growth w0=0
R6_2_7_2n q6_2_7_2 n7_2 2647391.233933647
X6_2_6_3p n6_2 m6_2_6_3 n5_3 n10_8 prune eta2=0.5 factor=0.5 factor2=0.07412822886721897 w0=0
X6_2_6_3m m6_2_6_3 p6_2_6_3 growth w0=0
R6_2_6_3p p6_2_6_3 n6_3 2647391.233933647
X6_2_6_3n q6_2_6_3 m6_2_6_3 growth w0=0
R6_2_6_3n q6_2_6_3 n6_3 2647391.233933647
X6_3_7_3p n7_3 m6_3_7_3 n5_3 n10_8 prune eta2=0.5 factor=0.5 factor2=0.07412822886721897 w0=0
X6_3_7_3m m6_3_7_3 p6_3_7_3 growth w0=0
R6_3_7_3p p6_3_7_3 n6_3 6006.050391399449
X6_3_7_3n q6_3_7_3 m6_3_7_3 growth w0=0
R6_3_7_3n q6_3_7_3 n6_3 3004981.5674761934
X6_3_6_4p n6_3 m6_3_6_4 n5_3 n10_8 prune eta2=0.5 factor=0.3106601717798213 factor2=0.08449937146256334 w0=0
X6_3_6_4m m6_3_6_4 p6_3_6_4 growth w0=0
R6_3_6_4p p6_3_6_4 n6_4 2647391.233933647
X6_3_6_4n q6_3_6_4 m6_3_6_4 growth w0=0
R6_3_6_4n q6_3_6_4 n6_4 2647391.233933647
X6_4_7_4p n6_4 m6_4_7_4 n5_3 n10_8 prune eta2=0.5 factor=0.21631189606246318 factor2=0.09333333333333334 w0=0
X6_4_7_4m m6_4_7_4 p6_4_7_4 growth w0=0
R6_4_7_4p p6_4_7_4 n7_4 2647391.233933647
X6_4_7_4n q6_4_7_4 m6_4_7_4 growth w0=0
R6_4_7_4n q6_4_7_4 n7_4 2647391.233933647
X6_4_6_5p n6_4 m6_4_6_5 n5_3 n10_8 prune eta2=0.5 factor=0.18541019662496844 factor2=0.09666666666666666 w0=0
X6_4_6_5m m6_4_6_5 p6_4_6_5 growth w0=0
R6_4_6_5p p6_4_6_5 n6_5 2647391.233933647
X6_4_6_5n q6_4_6_5 m6_4_6_5 growth w0=0
R6_4_6_5n q6_4_6_5 n6_5 2647391.233933647
X6_5_7_5p n6_5 m6_5_7_5 n5_3 n10_8 prune eta2=0.5 factor=0.1632524218523384 factor2=0.11126708240115196 w0=0
X6_5_7_5m m6_5_7_5 p6_5_7_5 growth w0=0
R6_5_7_5p p6_5_7_5 n7_5 2647391.233933647
X6_5_7_5n q6_5_7_5 m6_5_7_5 growth w0=0
R6_5_7_5n q6_5_7_5 n7_5 2647391.233933647
X6_5_6_6p n6_5 m6_5_6_6 n5_3 n10_8 prune eta2=0.5 factor=0.13213919034362318 factor2=0.10964639857893407 w0=0
X6_5_6_6m m6_5_6_6 p6_5_6_6 growth w0=0
R6_5_6_6p p6_5_6_6 n6_6 2647391.233933647
X6_5_6_6n q6_5_6_6 m6_5_6_6 growth w0=0
R6_5_6_6n q6_5_6_6 n6_6 2647391.233933647
X6_6_7_6p n6_6 m6_6_7_6 n5_3 n10_8 prune eta2=0.5 factor=0.125266888243461 factor2=0.13361801412635843 w0=0
X6_6_7_6m m6_6_7_6 p6_6_7_6 growth w0=0
R6_6_7_6p p6_6_7_6 n7_6 2647391.233933647
X6_6_7_6n q6_6_7_6 m6_6_7_6 growth w0=0
R6_6_7_6n q6_6_7_6 n7_6 2647391.233933647
X6_6_6_7p n6_6 m6_6_6_7 n5_3 n10_8 prune eta2=0.5 factor=0.10333805378881965 factor2=0.12056106275362292 w0=0
X6_6_6_7m m6_6_6_7 p6_6_6_7 growth w0=0
R6_6_6_7p p6_6_6_7 n6_7 2647391.233933647
X6_6_6_7n q6_6_6_7 m6_6_6_7 growth w0=0
R6_6_6_7n q6_6_6_7 n6_7 2647391.233933647
X6_7_7_7p n6_7 m6_7_7_7 n5_3 n10_8 prune eta2=0.5 factor=0.10050919869735625 factor2=0.15616449767882737 w0=0
X6_7_7_7m m6_7_7_7 p6_7_7_7 growth w0=0
R6_7_7_7p p6_7_7_7 n7_7 2647391.233933647
X6_7_7_7n q6_7_7_7 m6_7_7_7 growth w0=0
R6_7_7_7n q6_7_7_7 n7_7 2647391.233933647
X6_7_6_8p n6_7 m6_7_6_8 n5_3 n10_8 prune eta2=0.5 factor=0.08513348220538862 factor2=0.125 w0=0
X6_7_6_8m m6_7_6_8 p6_7_6_8 growth w0=0
R6_7_6_8p p6_7_6_8 n6_8 2647391.233933647
X6_7_6_8n q6_7_6_8 m6_7_6_8 growth w0=0
R6_7_6_8n q6_7_6_8 n6_8 2647391.233933647
X6_8_7_8p n6_8 m6_8_7_8 n5_3 n10_8 prune eta2=0.5 factor=0.08370696368298622 factor2=0.16666666666666666 w0=0
X6_8_7_8m m6_8_7_8 p6_8_7_8 growth w0=0
R6_8_7_8p p6_8_7_8 n7_8 6006.050391399449
X6_8_7_8n q6_8_7_8 m6_8_7_8 growth w0=0
R6_8_7_8n q6_8_7_8 n7_8 3004981.5674761934
X6_8_6_9p n6_8 m6_8_6_9 n5_3 n10_8 prune eta2=0.5 factor=0.07250186792467431 factor2=0.12056106275362292 w0=0
X6_8_6_9m m6_8_6_9 p6_8_6_9 growth w0=0
R6_8_6_9p p6_8_6_9 n6_9 2647391.233933647
X6_8_6_9n q6_8_6_9 m6_8_6_9 growth w0=0
R6_8_6_9n q6_8_6_9 n6_9 2647391.233933647
X6_9_7_9p n6_9 m6_9_7_9 n5_3 n10_8 prune eta2=0.5 factor=0.07167670623530252 factor2=0.15616449767882737 w0=0
X6_9_7_9m m6_9_7_9 p6_9_7_9 growth w0=0
R6_9_7_9p p6_9_7_9 n7_9 2647391.233933647
X6_9_7_9n q6_9_7_9 m6_9_7_9 growth w0=0
R6_9_7_9n q6_9_7_9 n7_9 2647391.233933647
X6_9_6_10p n6_9 m6_9_6_10 n5_3 n10_8 prune eta2=0.5 factor=0.06318866498064066 factor2=0.10964639857893407 w0=0
X6_9_6_10m m6_9_6_10 p6_9_6_10 growth w0=0
R6_9_6_10p p6_9_6_10 n6_10 2647391.233933647
X6_9_6_10n q6_9_6_10 m6_9_6_10 growth w0=0
R6_9_6_10n q6_9_6_10 n6_10 2647391.233933647
X6_10_7_10p n6_10 m6_10_7_10 n5_3 n10_8 prune eta2=0.5 factor=0.0626643766165509 factor2=0.13361801412635843 w0=0
X6_10_7_10m m6_10_7_10 p6_10_7_10 growth w0=0
R6_10_7_10p p6_10_7_10 n7_10 2647391.233933647
X6_10_7_10n q6_10_7_10 m6_10_7_10 growth w0=0
R6_10_7_10n q6_10_7_10 n7_10 2647391.233933647
X6_10_6_11p n6_10 m6_10_6_11 n5_3 n10_8 prune eta2=0.5 factor=0.0560227177148683 factor2=0.09666666666666666 w0=0
X6_10_6_11m m6_10_6_11 p6_10_6_11 growth w0=0
R6_10_6_11p p6_10_6_11 n6_11 2647391.233933647
X6_10_6_11n q6_10_6_11 m6_10_6_11 growth w0=0
R6_10_6_11n q6_10_6_11 n6_11 2647391.233933647
X6_11_7_11p n6_11 m6_11_7_11 n5_3 n10_8 prune eta2=0.5 factor=0.05566667993705799 factor2=0.11126708240115196 w0=0
X6_11_7_11m m6_11_7_11 p6_11_7_11 growth w0=0
R6_11_7_11p p6_11_7_11 n7_11 2647391.233933647
X6_11_7_11n q6_11_7_11 m6_11_7_11 growth w0=0
R6_11_7_11n q6_11_7_11 n7_11 2647391.233933647
X6_11_6_12p n6_11 m6_11_6_12 n5_3 n10_8 prune eta2=0.5 factor=0.05033099717445089 factor2=0.08449937146256334 w0=0
X6_11_6_12m m6_11_6_12 p6_11_6_12 growth w0=0
R6_11_6_12p p6_11_6_12 n6_12 2647391.233933647
X6_11_6_12n q6_11_6_12 m6_11_6_12 growth w0=0
R6_11_6_12n q6_11_6_12 n6_12 2647391.233933647
X6_12_7_12p n6_12 m6_12_7_12 n5_3 n10_8 prune eta2=0.5 factor=0.0500770565675407 factor2=0.09333333333333334 w0=0
X6_12_7_12m m6_12_7_12 p6_12_7_12 growth w0=0
R6_12_7_12p p6_12_7_12 n7_12 2647391.233933647
X6_12_7_12n q6_12_7_12 m6_12_7_12 growth w0=0
R6_12_7_12n q6_12_7_12 n7_12 2647391.233933647
X6_12_6_13p n6_12 m6_12_6_13 n5_3 n10_8 prune eta2=0.5 factor=0.0456973917502144 factor2=0.07412822886721897 w0=0
X6_12_6_13m m6_12_6_13 p6_12_6_13 growth w0=0
R6_12_6_13p p6_12_6_13 n6_13 2647391.233933647
X6_12_6_13n q6_12_6_13 m6_12_6_13 growth w0=0
R6_12_6_13n q6_12_6_13 n6_13 2647391.233933647
X6_13_7_13p n6_13 m6_13_7_13 n5_3 n10_8 prune eta2=0.5 factor=0.04550934171404361 factor2=0.07965473266901786 w0=0
X6_13_7_13m m6_13_7_13 p6_13_7_13 growth w0=0
R6_13_7_13p p6_13_7_13 n7_13 2647391.233933647
X6_13_7_13n q6_13_7_13 m6_13_7_13 growth w0=0
R6_13_7_13n q6_13_7_13 n7_13 2647391.233933647
X6_13_6_14p n6_13 m6_13_6_14 n5_3 n10_8 prune eta2=0.5 factor=0.04185000017321613 factor2=0.06557725166892284 w0=0
X6_13_6_14m m6_13_6_14 p6_13_6_14 growth w0=0
R6_13_6_14p p6_13_6_14 n6_14 2647391.233933647
X6_13_6_14n q6_13_6_14 m6_13_6_14 growth w0=0
R6_13_6_14n q6_13_6_14 n6_14 2647391.233933647
X6_14_7_14p n6_14 m6_14_7_14 n5_3 n10_8 prune eta2=0.5 factor=0.041706553732656984 factor2=0.06919035069696204 w0=0
X6_14_7_14m m6_14_7_14 p6_14_7_14 growth w0=0
R6_14_7_14p p6_14_7_14 n7_14 2647391.233933647
X6_14_7_14n q6_14_7_14 m6_14_7_14 growth w0=0
R6_14_7_14n q6_14_7_14 n7_14 2647391.233933647
X6_14_6_15p n6_14 m6_14_6_15 n5_3 n10_8 prune eta2=0.5 factor=0.038603276065701034 factor2=0.05856920488372595 w0=0
X6_14_6_15m m6_14_6_15 p6_14_6_15 growth w0=0
R6_14_6_15p p6_14_6_15 n6_15 2647391.233933647
X6_14_6_15n q6_14_6_15 m6_14_6_15 growth w0=0
R6_14_6_15n q6_14_6_15 n6_15 2647391.233933647
X6_15_7_15p n6_15 m6_15_7_15 n5_3 n10_8 prune eta2=0.5 factor=0.038491192293837705 factor2=0.06103480935536878 w0=0
X6_15_7_15m m6_15_7_15 p6_15_7_15 growth w0=0
R6_15_7_15p p6_15_7_15 n7_15 2647391.233933647
X6_15_7_15n q6_15_7_15 m6_15_7_15 growth w0=0
R6_15_7_15n q6_15_7_15 n7_15 2647391.233933647
X7_1_8_1p n7_1 m7_1_8_1 n5_3 n10_8 prune eta2=0.5 factor=0.13361801412635843 factor2=0.0626643766165509 w0=0
X7_1_8_1m m7_1_8_1 p7_1_8_1 growth w0=0
R7_1_8_1p p7_1_8_1 n8_1 2647391.233933647
X7_1_8_1n q7_1_8_1 m7_1_8_1 growth w0=0
R7_1_8_1n q7_1_8_1 n8_1 2647391.233933647
X7_1_7_2p n7_1 m7_1_7_2 n5_3 n10_8 prune eta2=0.5 factor=0.21631189606246318 factor2=0.06919035069696204 w0=0
X7_1_7_2m m7_1_7_2 p7_1_7_2 growth w0=0
R7_1_7_2p p7_1_7_2 n7_2 2647391.233933647
X7_1_7_2n q7_1_7_2 m7_1_7_2 growth w0=0
R7_1_7_2n q7_1_7_2 n7_2 2647391.233933647
X7_2_8_2p n7_2 m7_2_8_2 n5_3 n10_8 prune eta2=0.5 factor=0.15616449767882737 factor2=0.07167670623530252 w0=0
X7_2_8_2m m7_2_8_2 p7_2_8_2 growth w0=0
R7_2_8_2p p7_2_8_2 n8_2 2647391.233933647
X7_2_8_2n q7_2_8_2 m7_2_8_2 growth w0=0
R7_2_8_2n q7_2_8_2 n8_2 2647391.233933647
X7_2_7_3p n7_2 m7_2_7_3 n5_3 n10_8 prune eta2=0.5 factor=0.25 factor2=0.07965473266901786 w0=0
X7_2_7_3m m7_2_7_3 p7_2_7_3 growth w0=0
R7_2_7_3p p7_2_7_3 n7_3 2647391.233933647
X7_2_7_3n q7_2_7_3 m7_2_7_3 growth w0=0
R7_2_7_3n q7_2_7_3 n7_3 2647391.233933647
X7_3_8_3p n7_3 m7_3_8_3 n5_3 n10_8 prune eta2=0.5 factor=0.16666666666666666 factor2=0.08370696368298622 w0=0
X7_3_8_3m m7_3_8_3 p7_3_8_3 growth w0=0
R7_3_8_3p p7_3_8_3 n8_3 2647391.233933647
X7_3_8_3n q7_3_8_3 m7_3_8_3 growth w0=0
R7_3_8_3n q7_3_8_3 n8_3 2647391.233933647
X7_3_7_4p n7_4 m7_3_7_4 n5_3 n10_8 prune eta2=0.5 factor=0.25 factor2=0.07965473266901786 w0=0
X7_3_7_4m m7_3_7_4 p7_3_7_4 growth w0=0
R7_3_7_4p p7_3_7_4 n7_3 6006.050391399449
X7_3_7_4n q7_3_7_4 m7_3_7_4 growth w0=0
R7_3_7_4n q7_3_7_4 n7_3 3004981.5674761934
X7_4_8_4p n7_4 m7_4_8_4 n5_3 n10_8 prune eta2=0.5 factor=0.15616449767882737 factor2=0.10050919869735625 w0=0
X7_4_8_4m m7_4_8_4 p7_4_8_4 growth w0=0
R7_4_8_4p p7_4_8_4 n8_4 2647391.233933647
X7_4_8_4n q7_4_8_4 m7_4_8_4 growth w0=0
R7_4_8_4n q7_4_8_4 n8_4 2647391.233933647
X7_4_7_5p n7_5 m7_4_7_5 n5_3 n10_8 prune eta2=0.5 factor=0.21631189606246318 factor2=0.09333333333333334 w0=0
X7_4_7_5m m7_4_7_5 p7_4_7_5 growth w0=0
R7_4_7_5p p7_4_7_5 n7_4 6006.050391399449
X7_4_7_5n q7_4_7_5 m7_4_7_5 growth w0=0
R7_4_7_5n q7_4_7_5 n7_4 3004981.5674761934
X7_5_8_5p n8_5 m7_5_8_5 n5_3 n10_8 prune eta2=0.5 factor=0.1632524218523384 factor2=0.11126708240115196 w0=0
X7_5_8_5m m7_5_8_5 p7_5_8_5 growth w0=0
R7_5_8_5p p7_5_8_5 n7_5 6006.050391399449
X7_5_8_5n q7_5_8_5 m7_5_8_5 growth w0=0
R7_5_8_5n q7_5_8_5 n7_5 3004981.5674761934
X7_5_7_6p n7_5 m7_5_7_6 n5_3 n10_8 prune eta2=0.5 factor=0.125266888243461 factor2=0.13361801412635843 w0=0
X7_5_7_6m m7_5_7_6 p7_5_7_6 growth w0=0
R7_5_7_6p p7_5_7_6 n7_6 2647391.233933647
X7_5_7_6n q7_5_7_6 m7_5_7_6 growth w0=0
R7_5_7_6n q7_5_7_6 n7_6 2647391.233933647
X7_6_8_6p n7_6 m7_6_8_6 n5_3 n10_8 prune eta2=0.5 factor=0.11126708240115196 factor2=0.1632524218523384 w0=0
X7_6_8_6m m7_6_8_6 p7_6_8_6 growth w0=0
R7_6_8_6p p7_6_8_6 n8_6 2647391.233933647
X7_6_8_6n q7_6_8_6 m7_6_8_6 growth w0=0
R7_6_8_6n q7_6_8_6 n8_6 2647391.233933647
X7_6_7_7p n7_6 m7_6_7_7 n5_3 n10_8 prune eta2=0.5 factor=0.10050919869735625 factor2=0.15616449767882737 w0=0
X7_6_7_7m m7_6_7_7 p7_6_7_7 growth w0=0
R7_6_7_7p p7_6_7_7 n7_7 2647391.233933647
X7_6_7_7n q7_6_7_7 m7_6_7_7 growth w0=0
R7_6_7_7n q7_6_7_7 n7_7 2647391.233933647
X7_7_8_7p n7_7 m7_7_8_7 n5_3 n10_8 prune eta2=0.5 factor=0.09333333333333334 factor2=0.21631189606246318 w0=0
X7_7_8_7m m7_7_8_7 p7_7_8_7 growth w0=0
R7_7_8_7p p7_7_8_7 n8_7 2647391.233933647
X7_7_8_7n q7_7_8_7 m7_7_8_7 growth w0=0
R7_7_8_7n q7_7_8_7 n8_7 2647391.233933647
X7_7_7_8p n7_7 m7_7_7_8 n5_3 n10_8 prune eta2=0.5 factor=0.08370696368298622 factor2=0.16666666666666666 w0=0
X7_7_7_8m m7_7_7_8 p7_7_7_8 growth w0=0
R7_7_7_8p p7_7_7_8 n7_8 2647391.233933647
X7_7_7_8n q7_7_7_8 m7_7_7_8 growth w0=0
R7_7_7_8n q7_7_7_8 n7_8 2647391.233933647
X7_8_8_8p n7_8 m7_8_8_8 n5_3 n10_8 prune eta2=0.5 factor=0.07965473266901786 factor2=0.25 w0=0
X7_8_8_8m m7_8_8_8 p7_8_8_8 growth w0=0
R7_8_8_8p p7_8_8_8 n8_8 6006.050391399449
X7_8_8_8n q7_8_8_8 m7_8_8_8 growth w0=0
R7_8_8_8n q7_8_8_8 n8_8 3004981.5674761934
X7_8_7_9p n7_8 m7_8_7_9 n5_3 n10_8 prune eta2=0.5 factor=0.07167670623530252 factor2=0.15616449767882737 w0=0
X7_8_7_9m m7_8_7_9 p7_8_7_9 growth w0=0
R7_8_7_9p p7_8_7_9 n7_9 2647391.233933647
X7_8_7_9n q7_8_7_9 m7_8_7_9 growth w0=0
R7_8_7_9n q7_8_7_9 n7_9 2647391.233933647
X7_9_8_9p n7_9 m7_9_8_9 n5_3 n10_8 prune eta2=0.5 factor=0.06919035069696204 factor2=0.21631189606246318 w0=0
X7_9_8_9m m7_9_8_9 p7_9_8_9 growth w0=0
R7_9_8_9p p7_9_8_9 n8_9 2647391.233933647
X7_9_8_9n q7_9_8_9 m7_9_8_9 growth w0=0
R7_9_8_9n q7_9_8_9 n8_9 2647391.233933647
X7_9_7_10p n7_9 m7_9_7_10 n5_3 n10_8 prune eta2=0.5 factor=0.0626643766165509 factor2=0.13361801412635843 w0=0
X7_9_7_10m m7_9_7_10 p7_9_7_10 growth w0=0
R7_9_7_10p p7_9_7_10 n7_10 2647391.233933647
X7_9_7_10n q7_9_7_10 m7_9_7_10 growth w0=0
R7_9_7_10n q7_9_7_10 n7_10 2647391.233933647
X7_10_8_10p n7_10 m7_10_8_10 n5_3 n10_8 prune eta2=0.5 factor=0.06103480935536878 factor2=0.1632524218523384 w0=0
X7_10_8_10m m7_10_8_10 p7_10_8_10 growth w0=0
R7_10_8_10p p7_10_8_10 n8_10 2647391.233933647
X7_10_8_10n q7_10_8_10 m7_10_8_10 growth w0=0
R7_10_8_10n q7_10_8_10 n8_10 2647391.233933647
X7_10_7_11p n7_10 m7_10_7_11 n5_3 n10_8 prune eta2=0.5 factor=0.05566667993705799 factor2=0.11126708240115196 w0=0
X7_10_7_11m m7_10_7_11 p7_10_7_11 growth w0=0
R7_10_7_11p p7_10_7_11 n7_11 2647391.233933647
X7_10_7_11n q7_10_7_11 m7_10_7_11 growth w0=0
R7_10_7_11n q7_10_7_11 n7_11 2647391.233933647
X7_11_8_11p n7_11 m7_11_8_11 n5_3 n10_8 prune eta2=0.5 factor=0.05454188400343725 factor2=0.125266888243461 w0=0
X7_11_8_11m m7_11_8_11 p7_11_8_11 growth w0=0
R7_11_8_11p p7_11_8_11 n8_11 2647391.233933647
X7_11_8_11n q7_11_8_11 m7_11_8_11 growth w0=0
R7_11_8_11n q7_11_8_11 n8_11 2647391.233933647
X7_11_7_12p n7_11 m7_11_7_12 n5_3 n10_8 prune eta2=0.5 factor=0.0500770565675407 factor2=0.09333333333333334 w0=0
X7_11_7_12m m7_11_7_12 p7_11_7_12 growth w0=0
R7_11_7_12p p7_11_7_12 n7_12 2647391.233933647
X7_11_7_12n q7_11_7_12 m7_11_7_12 growth w0=0
R7_11_7_12n q7_11_7_12 n7_12 2647391.233933647
X7_12_8_12p n7_12 m7_12_8_12 n5_3 n10_8 prune eta2=0.5 factor=0.04926813153476766 factor2=0.10050919869735625 w0=0
X7_12_8_12m m7_12_8_12 p7_12_8_12 growth w0=0
R7_12_8_12p p7_12_8_12 n8_12 2647391.233933647
X7_12_8_12n q7_12_8_12 m7_12_8_12 growth w0=0
R7_12_8_12n q7_12_8_12 n8_12 2647391.233933647
X7_12_7_13p n7_12 m7_12_7_13 n5_3 n10_8 prune eta2=0.5 factor=0.04550934171404361 factor2=0.07965473266901786 w0=0
X7_12_7_13m m7_12_7_13 p7_12_7_13 growth w0=0
R7_12_7_13p p7_12_7_13 n7_13 2647391.233933647
X7_12_7_13n q7_12_7_13 m7_12_7_13 growth w0=0
R7_12_7_13n q7_12_7_13 n7_13 2647391.233933647
X7_13_8_13p n7_13 m7_13_8_13 n5_3 n10_8 prune eta2=0.5 factor=0.04490801601248648 factor2=0.08370696368298622 w0=0
X7_13_8_13m m7_13_8_13 p7_13_8_13 growth w0=0
R7_13_8_13p p7_13_8_13 n8_13 2647391.233933647
X7_13_8_13n q7_13_8_13 m7_13_8_13 growth w0=0
R7_13_8_13n q7_13_8_13 n8_13 2647391.233933647
X7_13_7_14p n7_13 m7_13_7_14 n5_3 n10_8 prune eta2=0.5 factor=0.041706553732656984 factor2=0.06919035069696204 w0=0
X7_13_7_14m m7_13_7_14 p7_13_7_14 growth w0=0
R7_13_7_14p p7_13_7_14 n7_14 2647391.233933647
X7_13_7_14n q7_13_7_14 m7_13_7_14 growth w0=0
R7_13_7_14n q7_13_7_14 n7_14 2647391.233933647
X7_14_8_14p n7_14 m7_14_8_14 n5_3 n10_8 prune eta2=0.5 factor=0.04124726640971537 factor2=0.07167670623530252 w0=0
X7_14_8_14m m7_14_8_14 p7_14_8_14 growth w0=0
R7_14_8_14p p7_14_8_14 n8_14 2647391.233933647
X7_14_8_14n q7_14_8_14 m7_14_8_14 growth w0=0
R7_14_8_14n q7_14_8_14 n8_14 2647391.233933647
X7_14_7_15p n7_14 m7_14_7_15 n5_3 n10_8 prune eta2=0.5 factor=0.038491192293837705 factor2=0.06103480935536878 w0=0
X7_14_7_15m m7_14_7_15 p7_14_7_15 growth w0=0
R7_14_7_15p p7_14_7_15 n7_15 2647391.233933647
X7_14_7_15n q7_14_7_15 m7_14_7_15 growth w0=0
R7_14_7_15n q7_14_7_15 n7_15 2647391.233933647
X7_15_8_15p n7_15 m7_15_8_15 n5_3 n10_8 prune eta2=0.5 factor=0.038132383745894935 factor2=0.0626643766165509 w0=0
X7_15_8_15m m7_15_8_15 p7_15_8_15 growth w0=0
R7_15_8_15p p7_15_8_15 n8_15 2647391.233933647
X7_15_8_15n q7_15_8_15 m7_15_8_15 growth w0=0
R7_15_8_15n q7_15_8_15 n8_15 2647391.233933647
X8_1_9_1p n8_1 m8_1_9_1 n5_3 n10_8 prune eta2=0.5 factor=0.10964639857893407 factor2=0.06318866498064066 w0=0
X8_1_9_1m m8_1_9_1 p8_1_9_1 growth w0=0
R8_1_9_1p p8_1_9_1 n9_1 2647391.233933647
X8_1_9_1n q8_1_9_1 m8_1_9_1 growth w0=0
R8_1_9_1n q8_1_9_1 n9_1 2647391.233933647
X8_1_8_2p n8_1 m8_1_8_2 n5_3 n10_8 prune eta2=0.5 factor=0.15616449767882737 factor2=0.07167670623530252 w0=0
X8_1_8_2m m8_1_8_2 p8_1_8_2 growth w0=0
R8_1_8_2p p8_1_8_2 n8_2 2647391.233933647
X8_1_8_2n q8_1_8_2 m8_1_8_2 growth w0=0
R8_1_8_2n q8_1_8_2 n8_2 2647391.233933647
X8_2_9_2p n8_2 m8_2_9_2 n5_3 n10_8 prune eta2=0.5 factor=0.12056106275362292 factor2=0.07250186792467431 w0=0
X8_2_9_2m m8_2_9_2 p8_2_9_2 growth w0=0
R8_2_9_2p p8_2_9_2 n9_2 2647391.233933647
X8_2_9_2n q8_2_9_2 m8_2_9_2 growth w0=0
R8_2_9_2n q8_2_9_2 n9_2 2647391.233933647
X8_2_8_3p n8_2 m8_2_8_3 n5_3 n10_8 prune eta2=0.5 factor=0.16666666666666666 factor2=0.08370696368298622 w0=0
X8_2_8_3m m8_2_8_3 p8_2_8_3 growth w0=0
R8_2_8_3p p8_2_8_3 n8_3 2647391.233933647
X8_2_8_3n q8_2_8_3 m8_2_8_3 growth w0=0
R8_2_8_3n q8_2_8_3 n8_3 2647391.233933647
X8_3_9_3p n8_3 m8_3_9_3 n5_3 n10_8 prune eta2=0.5 factor=0.125 factor2=0.08513348220538862 w0=0
X8_3_9_3m m8_3_9_3 p8_3_9_3 growth w0=0
R8_3_9_3p p8_3_9_3 n9_3 2647391.233933647
X8_3_9_3n q8_3_9_3 m8_3_9_3 growth w0=0
R8_3_9_3n q8_3_9_3 n9_3 2647391.233933647
X8_3_8_4p n8_3 m8_3_8_4 n5_3 n10_8 prune eta2=0.5 factor=0.15616449767882737 factor2=0.10050919869735625 w0=0
X8_3_8_4m m8_3_8_4 p8_3_8_4 growth w0=0
R8_3_8_4p p8_3_8_4 n8_4 2647391.233933647
X8_3_8_4n q8_3_8_4 m8_3_8_4 growth w0=0
R8_3_8_4n q8_3_8_4 n8_4 2647391.233933647
X8_4_9_4p n8_4 m8_4_9_4 n5_3 n10_8 prune eta2=0.5 factor=0.12056106275362292 factor2=0.10333805378881965 w0=0
X8_4_9_4m m8_4_9_4 p8_4_9_4 growth w0=0
R8_4_9_4p p8_4_9_4 n9_4 2647391.233933647
X8_4_9_4n q8_4_9_4 m8_4_9_4 growth w0=0
R8_4_9_4n q8_4_9_4 n9_4 2647391.233933647
X8_4_8_5p n8_4 m8_4_8_5 n5_3 n10_8 prune eta2=0.5 factor=0.13361801412635843 factor2=0.125266888243461 w0=0
X8_4_8_5m m8_4_8_5 p8_4_8_5 growth w0=0
R8_4_8_5p p8_4_8_5 n8_5 2647391.233933647
X8_4_8_5n q8_4_8_5 m8_4_8_5 growth w0=0
R8_4_8_5n q8_4_8_5 n8_5 2647391.233933647
X8_5_9_5p n8_5 m8_5_9_5 n5_3 n10_8 prune eta2=0.5 factor=0.10964639857893407 factor2=0.13213919034362318 w0=0
X8_5_9_5m m8_5_9_5 p8_5_9_5 growth w0=0
R8_5_9_5p p8_5_9_5 n9_5 2647391.233933647
X8_5_9_5n q8_5_9_5 m8_5_9_5 growth w0=0
R8_5_9_5n q8_5_9_5 n9_5 2647391.233933647
X8_5_8_6p n8_6 m8_5_8_6 n5_3 n10_8 prune eta2=0.5 factor=0.13361801412635843 factor2=0.125266888243461 w0=0
X8_5_8_6m m8_5_8_6 p8_5_8_6 growth w0=0
R8_5_8_6p p8_5_8_6 n8_5 6006.050391399449
X8_5_8_6n q8_5_8_6 m8_5_8_6 growth w0=0
R8_5_8_6n q8_5_8_6 n8_5 3004981.5674761934
X8_6_9_6p n9_6 m8_6_9_6 n5_3 n10_8 prune eta2=0.5 factor=0.11126708240115196 factor2=0.1632524218523384 w0=0
X8_6_9_6m m8_6_9_6 p8_6_9_6 growth w0=0
R8_6_9_6p p8_6_9_6 n8_6 6006.050391399449
X8_6_9_6n q8_6_9_6 m8_6_9_6 growth w0=0
R8_6_9_6n q8_6_9_6 n8_6 3004981.5674761934
X8_6_8_7p n8_6 m8_6_8_7 n5_3 n10_8 prune eta2=0.5 factor=0.09333333333333334 factor2=0.21631189606246318 w0=0
X8_6_8_7m m8_6_8_7 p8_6_8_7 growth w0=0
R8_6_8_7p p8_6_8_7 n8_7 2647391.233933647
X8_6_8_7n q8_6_8_7 m8_6_8_7 growth w0=0
R8_6_8_7n q8_6_8_7 n8_7 2647391.233933647
X8_7_9_7p n8_7 m8_7_9_7 n5_3 n10_8 prune eta2=0.5 factor=0.08449937146256334 factor2=0.3106601717798213 w0=0
X8_7_9_7m m8_7_9_7 p8_7_9_7 growth w0=0
R8_7_9_7p p8_7_9_7 n9_7 2647391.233933647
X8_7_9_7n q8_7_9_7 m8_7_9_7 growth w0=0
R8_7_9_7n q8_7_9_7 n9_7 2647391.233933647
X8_7_8_8p n8_7 m8_7_8_8 n5_3 n10_8 prune eta2=0.5 factor=0.07965473266901786 factor2=0.25 w0=0
X8_7_8_8m m8_7_8_8 p8_7_8_8 growth w0=0
R8_7_8_8p p8_7_8_8 n8_8 2647391.233933647
X8_7_8_8n q8_7_8_8 m8_7_8_8 growth w0=0
R8_7_8_8n q8_7_8_8 n8_8 2647391.233933647
X8_8_9_8p n8_8 m8_8_9_8 n5_3 n10_8 prune eta2=0.5 factor=0.07412822886721897 factor2=0.5 w0=0
X8_8_9_8m m8_8_9_8 p8_8_9_8 growth w0=0
R8_8_9_8p p8_8_9_8 n9_8 6006.050391399449
X8_8_9_8n q8_8_9_8 m8_8_9_8 growth w0=0
R8_8_9_8n q8_8_9_8 n9_8 3004981.5674761934
X8_8_8_9p n8_8 m8_8_8_9 n5_3 n10_8 prune eta2=0.5 factor=0.06919035069696204 factor2=0.21631189606246318 w0=0
X8_8_8_9m m8_8_8_9 p8_8_8_9 growth w0=0
R8_8_8_9p p8_8_8_9 n8_9 2647391.233933647
X8_8_8_9n q8_8_8_9 m8_8_8_9 growth w0=0
R8_8_8_9n q8_8_8_9 n8_9 2647391.233933647
X8_9_9_9p n8_9 m8_9_9_9 n5_3 n10_8 prune eta2=0.5 factor=0.06557725166892284 factor2=0.3106601717798213 w0=0
X8_9_9_9m m8_9_9_9 p8_9_9_9 growth w0=0
R8_9_9_9p p8_9_9_9 n9_9 2647391.233933647
X8_9_9_9n q8_9_9_9 m8_9_9_9 growth w0=0
R8_9_9_9n q8_9_9_9 n9_9 2647391.233933647
X8_9_8_10p n8_9 m8_9_8_10 n5_3 n10_8 prune eta2=0.5 factor=0.06103480935536878 factor2=0.1632524218523384 w0=0
X8_9_8_10m m8_9_8_10 p8_9_8_10 growth w0=0
R8_9_8_10p p8_9_8_10 n8_10 2647391.233933647
X8_9_8_10n q8_9_8_10 m8_9_8_10 growth w0=0
R8_9_8_10n q8_9_8_10 n8_10 2647391.233933647
X8_10_9_10p n8_10 m8_10_9_10 n5_3 n10_8 prune eta2=0.5 factor=0.05856920488372595 factor2=0.18541019662496844 w0=0
X8_10_9_10m m8_10_9_10 p8_10_9_10 growth w0=0
R8_10_9_10p p8_10_9_10 n9_10 2647391.233933647
X8_10_9_10n q8_10_9_10 m8_10_9_10 growth w0=0
R8_10_9_10n q8_10_9_10 n9_10 2647391.233933647
X8_10_8_11p n8_10 m8_10_8_11 n5_3 n10_8 prune eta2=0.5 factor=0.05454188400343725 factor2=0.125266888243461 w0=0
X8_10_8_11m m8_10_8_11 p8_10_8_11 growth w0=0
R8_10_8_11p p8_10_8_11 n8_11 2647391.233933647
X8_10_8_11n q8_10_8_11 m8_10_8_11 growth w0=0
R8_10_8_11n q8_10_8_11 n8_11 2647391.233933647
X8_11_9_11p n8_11 m8_11_9_11 n5_3 n10_8 prune eta2=0.5 factor=0.05279421206012099 factor2=0.13213919034362318 w0=0
X8_11_9_11m m8_11_9_11 p8_11_9_11 growth w0=0
R8_11_9_11p p8_11_9_11 n9_11 2647391.233933647
X8_11_9_11n q8_11_9_11 m8_11_9_11 growth w0=0
R8_11_9_11n q8_11_9_11 n9_11 2647391.233933647
X8_11_8_12p n8_11 m8_11_8_12 n5_3 n10_8 prune eta2=0.5 factor=0.04926813153476766 factor2=0.10050919869735625 w0=0
X8_11_8_12m m8_11_8_12 p8_11_8_12 growth w0=0
R8_11_8_12p p8_11_8_12 n8_12 2647391.233933647
X8_11_8_12n q8_11_8_12 m8_11_8_12 growth w0=0
R8_11_8_12n q8_11_8_12 n8_12 2647391.233933647
X8_12_9_12p n8_12 m8_12_9_12 n5_3 n10_8 prune eta2=0.5 factor=0.04798832892941402 factor2=0.10333805378881965 w0=0
X8_12_9_12m m8_12_9_12 p8_12_9_12 growth w0=0
R8_12_9_12p p8_12_9_12 n9_12 2647391.233933647
X8_12_9_12n q8_12_9_12 m8_12_9_12 growth w0=0
R8_12_9_12n q8_12_9_12 n9_12 2647391.233933647
X8_12_8_13p n8_12 m8_12_8_13 n5_3 n10_8 prune eta2=0.5 factor=0.04490801601248648 factor2=0.08370696368298622 w0=0
X8_12_8_13m m8_12_8_13 p8_12_8_13 growth w0=0
R8_12_8_13p p8_12_8_13 n8_13 2647391.233933647
X8_12_8_13n q8_12_8_13 m8_12_8_13 growth w0=0
R8_12_8_13n q8_12_8_13 n8_13 2647391.233933647
X8_13_9_13p n8_13 m8_13_9_13 n5_3 n10_8 prune eta2=0.5 factor=0.04394451100870619 factor2=0.08513348220538862 w0=0
X8_13_9_13m m8_13_9_13 p8_13_9_13 growth w0=0
R8_13_9_13p p8_13_9_13 n9_13 2647391.233933647
X8_13_9_13n q8_13_9_13 m8_13_9_13 growth w0=0
R8_13_9_13n q8_13_9_13 n9_13 2647391.233933647
X8_13_8_14p n8_13 m8_13_8_14 n5_3 n10_8 prune eta2=0.5 factor=0.04124726640971537 factor2=0.07167670623530252 w0=0
X8_13_8_14m m8_13_8_14 p8_13_8_14 growth w0=0
R8_13_8_14p p8_13_8_14 n8_14 2647391.233933647
X8_13_8_14n q8_13_8_14 m8_13_8_14 growth w0=0
R8_13_8_14n q8_13_8_14 n8_14 2647391.233933647
X8_14_9_14p n8_14 m8_14_9_14 n5_3 n10_8 prune eta2=0.5 factor=0.04050458049086161 factor2=0.07250186792467431 w0=0
X8_14_9_14m m8_14_9_14 p8_14_9_14 growth w0=0
R8_14_9_14p p8_14_9_14 n9_14 2647391.233933647
X8_14_9_14n q8_14_9_14 m8_14_9_14 growth w0=0
R8_14_9_14n q8_14_9_14 n9_14 2647391.233933647
X8_14_8_15p n8_14 m8_14_8_15 n5_3 n10_8 prune eta2=0.5 factor=0.038132383745894935 factor2=0.0626643766165509 w0=0
X8_14_8_15m m8_14_8_15 p8_14_8_15 growth w0=0
R8_14_8_15p p8_14_8_15 n8_15 2647391.233933647
X8_14_8_15n q8_14_8_15 m8_14_8_15 growth w0=0
R8_14_8_15n q8_14_8_15 n8_15 2647391.233933647
X8_15_9_15p n8_15 m8_15_9_15 n5_3 n10_8 prune eta2=0.5 factor=0.037548233983303 factor2=0.06318866498064066 w0=0
X8_15_9_15m m8_15_9_15 p8_15_9_15 growth w0=0
R8_15_9_15p p8_15_9_15 n9_15 2647391.233933647
X8_15_9_15n q8_15_9_15 m8_15_9_15 growth w0=0
R8_15_9_15n q8_15_9_15 n9_15 2647391.233933647
X9_1_10_1p n9_1 m9_1_10_1 n5_3 n10_8 prune eta2=0.5 factor=0.09180763758779135 factor2=0.0625 w0=0
X9_1_10_1m m9_1_10_1 p9_1_10_1 growth w0=0
R9_1_10_1p p9_1_10_1 n10_1 2647391.233933647
X9_1_10_1n q9_1_10_1 m9_1_10_1 growth w0=0
R9_1_10_1n q9_1_10_1 n10_1 2647391.233933647
X9_1_9_2p n9_1 m9_1_9_2 n5_3 n10_8 prune eta2=0.5 factor=0.12056106275362292 factor2=0.07250186792467431 w0=0
X9_1_9_2m m9_1_9_2 p9_1_9_2 growth w0=0
R9_1_9_2p p9_1_9_2 n9_2 2647391.233933647
X9_1_9_2n q9_1_9_2 m9_1_9_2 growth w0=0
R9_1_9_2n q9_1_9_2 n9_2 2647391.233933647
X9_2_10_2p n9_2 m9_2_10_2 n5_3 n10_8 prune eta2=0.5 factor=0.09774584993952026 factor2=0.07142857142857142 w0=0
X9_2_10_2m m9_2_10_2 p9_2_10_2 growth w0=0
R9_2_10_2p p9_2_10_2 n10_2 2647391.233933647
X9_2_10_2n q9_2_10_2 m9_2_10_2 growth w0=0
R9_2_10_2n q9_2_10_2 n10_2 2647391.233933647
X9_2_9_3p n9_2 m9_2_9_3 n5_3 n10_8 prune eta2=0.5 factor=0.125 factor2=0.08513348220538862 w0=0
X9_2_9_3m m9_2_9_3 p9_2_9_3 growth w0=0
R9_2_9_3p p9_2_9_3 n9_3 2647391.233933647
X9_2_9_3n q9_2_9_3 m9_2_9_3 growth w0=0
R9_2_9_3n q9_2_9_3 n9_3 2647391.233933647
X9_3_10_3p n9_3 m9_3_10_3 n5_3 n10_8 prune eta2=0.5 factor=0.09999999999999999 factor2=0.08333333333333333 w0=0
X9_3_10_3m m9_3_10_3 p9_3_10_3 growth w0=0
R9_3_10_3p p9_3_10_3 n10_3 2647391.233933647
X9_3_10_3n q9_3_10_3 m9_3_10_3 growth w0=0
R9_3_10_3n q9_3_10_3 n10_3 2647391.233933647
X9_3_9_4p n9_3 m9_3_9_4 n5_3 n10_8 prune eta2=0.5 factor=0.12056106275362292 factor2=0.10333805378881965 w0=0
X9_3_9_4m m9_3_9_4 p9_3_9_4 growth w0=0
R9_3_9_4p p9_3_9_4 n9_4 2647391.233933647
X9_3_9_4n q9_3_9_4 m9_3_9_4 growth w0=0
R9_3_9_4n q9_3_9_4 n9_4 2647391.233933647
X9_4_10_4p n9_4 m9_4_10_4 n5_3 n10_8 prune eta2=0.5 factor=0.09774584993952026 factor2=0.1 w0=0
X9_4_10_4m m9_4_10_4 p9_4_10_4 growth w0=0
R9_4_10_4p p9_4_10_4 n10_4 2647391.233933647
X9_4_10_4n q9_4_10_4 m9_4_10_4 growth w0=0
R9_4_10_4n q9_4_10_4 n10_4 2647391.233933647
X9_4_9_5p n9_4 m9_4_9_5 n5_3 n10_8 prune eta2=0.5 factor=0.10964639857893407 factor2=0.13213919034362318 w0=0
X9_4_9_5m m9_4_9_5 p9_4_9_5 growth w0=0
R9_4_9_5p p9_4_9_5 n9_5 2647391.233933647
X9_4_9_5n q9_4_9_5 m9_4_9_5 growth w0=0
R9_4_9_5n q9_4_9_5 n9_5 2647391.233933647
X9_5_10_5p n9_5 m9_5_10_5 n5_3 n10_8 prune eta2=0.5 factor=0.09180763758779135 factor2=0.125 w0=0
X9_5_10_5m m9_5_10_5 p9_5_10_5 growth w0=0
R9_5_10_5p p9_5_10_5 n10_5 2647391.233933647
X9_5_10_5n q9_5_10_5 m9_5_10_5 growth w0=0
R9_5_10_5n q9_5_10_5 n10_5 2647391.233933647
X9_5_9_6p n9_5 m9_5_9_6 n5_3 n10_8 prune eta2=0.5 factor=0.09666666666666666 factor2=0.18541019662496844 w0=0
X9_5_9_6m m9_5_9_6 p9_5_9_6 growth w0=0
R9_5_9_6p p9_5_9_6 n9_6 2647391.233933647
X9_5_9_6n q9_5_9_6 m9_5_9_6 growth w0=0
R9_5_9_6n q9_5_9_6 n9_6 2647391.233933647
X9_6_10_6p n10_6 m9_6_10_6 n5_3 n10_8 prune eta2=0.5 factor=0.09666666666666666 factor2=0.18541019662496844 w0=0
X9_6_10_6m m9_6_10_6 p9_6_10_6 growth w0=0
R9_6_10_6p p9_6_10_6 n9_6 6006.050391399449
X9_6_10_6n q9_6_10_6 m9_6_10_6 growth w0=0
R9_6_10_6n q9_6_10_6 n9_6 3004981.5674761934
X9_6_9_7p n9_6 m9_6_9_7 n5_3 n10_8 prune eta2=0.5 factor=0.08449937146256334 factor2=0.3106601717798213 w0=0
X9_6_9_7m m9_6_9_7 p9_6_9_7 growth w0=0
R9_6_9_7p p9_6_9_7 n9_7 2647391.233933647
X9_6_9_7n q9_6_9_7 m9_6_9_7 growth w0=0
R9_6_9_7n q9_6_9_7 n9_7 2647391.233933647
X9_7_10_7p n9_7 m9_7_10_7 n5_3 n10_8 prune eta2=0.5 factor=0.07577552284204606 factor2=0.25 w0=0
X9_7_10_7m m9_7_10_7 p9_7_10_7 growth w0=0
R9_7_10_7p p9_7_10_7 n10_7 2647391.233933647
X9_7_10_7n q9_7_10_7 m9_7_10_7 growth w0=0
R9_7_10_7n q9_7_10_7 n10_7 2647391.233933647
X9_7_9_8p n9_7 m9_7_9_8 n5_3 n10_8 prune eta2=0.5 factor=0.07412822886721897 factor2=0.5 w0=0
X9_7_9_8m m9_7_9_8 p9_7_9_8 growth w0=0
R9_7_9_8p p9_7_9_8 n9_8 2647391.233933647
X9_7_9_8n q9_7_9_8 m9_7_9_8 growth w0=0
R9_7_9_8n q9_7_9_8 n9_8 2647391.233933647
X9_8_9_9p n9_8 m9_8_9_9 n5_3 n10_8 prune eta2=0.5 factor=0.06557725166892284 factor2=0.3106601717798213 w0=0
X9_8_9_9m m9_8_9_9 p9_8_9_9 growth w0=0
R9_8_9_9p p9_8_9_9 n9_9 2647391.233933647
X9_8_9_9n q9_8_9_9 m9_8_9_9 growth w0=0
R9_8_9_9n q9_8_9_9 n9_9 2647391.233933647
X9_9_10_9p n9_9 m9_9_10_9 n5_3 n10_8 prune eta2=0.5 factor=0.061403890520469843 factor2=0.25 w0=0
X9_9_10_9m m9_9_10_9 p9_9_10_9 growth w0=0
R9_9_10_9p p9_9_10_9 n10_9 2647391.233933647
X9_9_10_9n q9_9_10_9 m9_9_10_9 growth w0=0
R9_9_10_9n q9_9_10_9 n10_9 2647391.233933647
X9_9_9_10p n9_9 m9_9_9_10 n5_3 n10_8 prune eta2=0.5 factor=0.05856920488372595 factor2=0.18541019662496844 w0=0
X9_9_9_10m m9_9_9_10 p9_9_9_10 growth w0=0
R9_9_9_10p p9_9_9_10 n9_10 2647391.233933647
X9_9_9_10n q9_9_9_10 m9_9_9_10 growth w0=0
R9_9_9_10n q9_9_9_10 n9_10 2647391.233933647
X9_10_10_10p n9_10 m9_10_10_10 n5_3 n10_8 prune eta2=0.5 factor=0.055589012967083254 factor2=0.16666666666666666 w0=0
X9_10_10_10m m9_10_10_10 p9_10_10_10 growth w0=0
R9_10_10_10p p9_10_10_10 n10_10 2647391.233933647
X9_10_10_10n q9_10_10_10 m9_10_10_10 growth w0=0
R9_10_10_10n q9_10_10_10 n10_10 2647391.233933647
X9_10_9_11p n9_10 m9_10_9_11 n5_3 n10_8 prune eta2=0.5 factor=0.05279421206012099 factor2=0.13213919034362318 w0=0
X9_10_9_11m m9_10_9_11 p9_10_9_11 growth w0=0
R9_10_9_11p p9_10_9_11 n9_11 2647391.233933647
X9_10_9_11n q9_10_9_11 m9_10_9_11 growth w0=0
R9_10_9_11n q9_10_9_11 n9_11 2647391.233933647
X9_11_10_11p n9_11 m9_11_10_11 n5_3 n10_8 prune eta2=0.5 factor=0.05061250168624366 factor2=0.125 w0=0
X9_11_10_11m m9_11_10_11 p9_11_10_11 growth w0=0
R9_11_10_11p p9_11_10_11 n10_11 2647391.233933647
X9_11_10_11n q9_11_10_11 m9_11_10_11 growth w0=0
R9_11_10_11n q9_11_10_11 n10_11 2647391.233933647
X9_11_9_12p n9_11 m9_11_9_12 n5_3 n10_8 prune eta2=0.5 factor=0.04798832892941402 factor2=0.10333805378881965 w0=0
X9_11_9_12m m9_11_9_12 p9_11_9_12 growth w0=0
R9_11_9_12p p9_11_9_12 n9_12 2647391.233933647
X9_11_9_12n q9_11_9_12 m9_11_9_12 growth w0=0
R9_11_9_12n q9_11_9_12 n9_12 2647391.233933647
X9_12_10_12p n9_12 m9_12_10_12 n5_3 n10_8 prune eta2=0.5 factor=0.046352872670689896 factor2=0.1 w0=0
X9_12_10_12m m9_12_10_12 p9_12_10_12 growth w0=0
R9_12_10_12p p9_12_10_12 n10_12 2647391.233933647
X9_12_10_12n q9_12_10_12 m9_12_10_12 growth w0=0
R9_12_10_12n q9_12_10_12 n10_12 2647391.233933647
X9_12_9_13p n9_12 m9_12_9_13 n5_3 n10_8 prune eta2=0.5 factor=0.04394451100870619 factor2=0.08513348220538862 w0=0
X9_12_9_13m m9_12_9_13 p9_12_9_13 growth w0=0
R9_12_9_13p p9_12_9_13 n9_13 2647391.233933647
X9_12_9_13n q9_12_9_13 m9_12_9_13 growth w0=0
R9_12_9_13n q9_12_9_13 n9_13 2647391.233933647
X9_13_10_13p n9_13 m9_13_10_13 n5_3 n10_8 prune eta2=0.5 factor=0.04269174791531817 factor2=0.08333333333333333 w0=0
X9_13_10_13m m9_13_10_13 p9_13_10_13 growth w0=0
R9_13_10_13p p9_13_10_13 n10_13 2647391.233933647
X9_13_10_13n q9_13_10_13 m9_13_10_13 growth w0=0
R9_13_10_13n q9_13_10_13 n10_13 2647391.233933647
X9_13_9_14p n9_13 m9_13_9_14 n5_3 n10_8 prune eta2=0.5 factor=0.04050458049086161 factor2=0.07250186792467431 w0=0
X9_13_9_14m m9_13_9_14 p9_13_9_14 growth w0=0
R9_13_9_14p p9_13_9_14 n9_14 2647391.233933647
X9_13_9_14n q9_13_9_14 m9_13_9_14 growth w0=0
R9_13_9_14n q9_13_9_14 n9_14 2647391.233933647
X9_14_10_14p n9_14 m9_14_10_14 n5_3 n10_8 prune eta2=0.5 factor=0.03952621497432169 factor2=0.07142857142857142 w0=0
X9_14_10_14m m9_14_10_14 p9_14_10_14 growth w0=0
R9_14_10_14p p9_14_10_14 n10_14 2647391.233933647
X9_14_10_14n q9_14_10_14 m9_14_10_14 growth w0=0
R9_14_10_14n q9_14_10_14 n10_14 2647391.233933647
X9_14_9_15p n9_14 m9_14_9_15 n5_3 n10_8 prune eta2=0.5 factor=0.037548233983303 factor2=0.06318866498064066 w0=0
X9_14_9_15m m9_14_9_15 p9_14_9_15 growth w0=0
R9_14_9_15p p9_14_9_15 n9_15 2647391.233933647
X9_14_9_15n q9_14_9_15 m9_14_9_15 growth w0=0
R9_14_9_15n q9_14_9_15 n9_15 2647391.233933647
X9_15_10_15p n9_15 m9_15_10_15 n5_3 n10_8 prune eta2=0.5 factor=0.036770921386306 factor2=0.0625 w0=0
X9_15_10_15m m9_15_10_15 p9_15_10_15 growth w0=0
R9_15_10_15p p9_15_10_15 n10_15 2647391.233933647
X9_15_10_15n q9_15_10_15 m9_15_10_15 growth w0=0
R9_15_10_15n q9_15_10_15 n10_15 2647391.233933647
X10_1_11_1p n10_1 m10_1_11_1 n5_3 n10_8 prune eta2=0.5 factor=0.07850305921009322 factor2=0.06071067811865475 w0=0
X10_1_11_1m m10_1_11_1 p10_1_11_1 growth w0=0
R10_1_11_1p p10_1_11_1 n11_1 2647391.233933647
X10_1_11_1n q10_1_11_1 m10_1_11_1 growth w0=0
R10_1_11_1n q10_1_11_1 n11_1 2647391.233933647
X10_1_10_2p n10_1 m10_1_10_2 n5_3 n10_8 prune eta2=0.5 factor=0.09774584993952026 factor2=0.07142857142857142 w0=0
X10_1_10_2m m10_1_10_2 p10_1_10_2 growth w0=0
R10_1_10_2p p10_1_10_2 n10_2 2647391.233933647
X10_1_10_2n q10_1_10_2 m10_1_10_2 growth w0=0
R10_1_10_2n q10_1_10_2 n10_2 2647391.233933647
X10_2_11_2p n10_2 m10_2_11_2 n5_3 n10_8 prune eta2=0.5 factor=0.08204158738844725 factor2=0.06868598013916513 w0=0
X10_2_11_2m m10_2_11_2 p10_2_11_2 growth w0=0
R10_2_11_2p p10_2_11_2 n11_2 2647391.233933647
X10_2_11_2n q10_2_11_2 m10_2_11_2 growth w0=0
R10_2_11_2n q10_2_11_2 n11_2 2647391.233933647
X10_2_10_3p n10_2 m10_2_10_3 n5_3 n10_8 prune eta2=0.5 factor=0.09999999999999999 factor2=0.08333333333333333 w0=0
X10_2_10_3m m10_2_10_3 p10_2_10_3 growth w0=0
R10_2_10_3p p10_2_10_3 n10_3 2647391.233933647
X10_2_10_3n q10_2_10_3 m10_2_10_3 growth w0=0
R10_2_10_3n q10_2_10_3 n10_3 2647391.233933647
X10_3_11_3p n10_3 m10_3_11_3 n5_3 n10_8 prune eta2=0.5 factor=0.08333333333333334 factor2=0.07882729833832279 w0=0
X10_3_11_3m m10_3_11_3 p10_3_11_3 growth w0=0
R10_3_11_3p p10_3_11_3 n11_3 2647391.233933647
X10_3_11_3n q10_3_11_3 m10_3_11_3 growth w0=0
R10_3_11_3n q10_3_11_3 n11_3 2647391.233933647
X10_3_10_4p n10_3 m10_3_10_4 n5_3 n10_8 prune eta2=0.5 factor=0.09774584993952026 factor2=0.1 w0=0
X10_3_10_4m m10_3_10_4 p10_3_10_4 growth w0=0
R10_3_10_4p p10_3_10_4 n10_4 2647391.233933647
X10_3_10_4n q10_3_10_4 m10_3_10_4 growth w0=0
R10_3_10_4n q10_3_10_4 n10_4 2647391.233933647
X10_4_11_4p n10_4 m10_4_11_4 n5_3 n10_8 prune eta2=0.5 factor=0.08204158738844725 factor2=0.09185604781228413 w0=0
X10_4_11_4m m10_4_11_4 p10_4_11_4 growth w0=0
R10_4_11_4p p10_4_11_4 n11_4 2647391.233933647
X10_4_11_4n q10_4_11_4 m10_4_11_4 growth w0=0
R10_4_11_4n q10_4_11_4 n11_4 2647391.233933647
X10_4_10_5p n10_4 m10_4_10_5 n5_3 n10_8 prune eta2=0.5 factor=0.09180763758779135 factor2=0.125 w0=0
X10_4_10_5m m10_4_10_5 p10_4_10_5 growth w0=0
R10_4_10_5p p10_4_10_5 n10_5 2647391.233933647
X10_4_10_5n q10_4_10_5 m10_4_10_5 growth w0=0
R10_4_10_5n q10_4_10_5 n10_5 2647391.233933647
X10_5_11_5p n10_5 m10_5_11_5 n5_3 n10_8 prune eta2=0.5 factor=0.07850305921009322 factor2=0.10811388300841895 w0=0
X10_5_11_5m m10_5_11_5 p10_5_11_5 growth w0=0
R10_5_11_5p p10_5_11_5 n11_5 2647391.233933647
X10_5_11_5n q10_5_11_5 m10_5_11_5 growth w0=0
R10_5_11_5n q10_5_11_5 n11_5 2647391.233933647
X10_5_10_6p n10_5 m10_5_10_6 n5_3 n10_8 prune eta2=0.5 factor=0.08396039389437018 factor2=0.16666666666666666 w0=0
X10_5_10_6m m10_5_10_6 p10_5_10_6 growth w0=0
R10_5_10_6p p10_5_10_6 n10_6 2647391.233933647
X10_5_10_6n q10_5_10_6 m10_5_10_6 growth w0=0
R10_5_10_6n q10_5_10_6 n10_6 2647391.233933647
X10_6_11_6p n11_6 m10_6_11_6 n5_3 n10_8 prune eta2=0.5 factor=0.08396039389437018 factor2=0.16666666666666666 w0=0
X10_6_11_6m m10_6_11_6 p10_6_11_6 growth w0=0
R10_6_11_6p p10_6_11_6 n10_6 6006.050391399449
X10_6_11_6n q10_6_11_6 m10_6_11_6 growth w0=0
R10_6_11_6n q10_6_11_6 n10_6 3004981.5674761934
X10_6_10_7p n10_6 m10_6_10_7 n5_3 n10_8 prune eta2=0.5 factor=0.07577552284204606 factor2=0.25 w0=0
X10_6_10_7m m10_6_10_7 p10_6_10_7 growth w0=0
R10_6_10_7p p10_6_10_7 n10_7 2647391.233933647
X10_6_10_7n q10_6_10_7 m10_6_10_7 growth w0=0
R10_6_10_7n q10_6_10_7 n10_7 2647391.233933647
X10_7_11_7p n10_7 m10_7_11_7 n5_3 n10_8 prune eta2=0.5 factor=0.06791929637138439 factor2=0.10355339059327377 w0=0
X10_7_11_7m m10_7_11_7 p10_7_11_7 growth w0=0
R10_7_11_7p p10_7_11_7 n11_7 2647391.233933647
X10_7_11_7n q10_7_11_7 m10_7_11_7 growth w0=0
R10_7_11_7n q10_7_11_7 n11_7 2647391.233933647
X10_7_10_8p n10_7 m10_7_10_8 n5_3 n10_8 prune eta2=0.5 factor=0.06814463870461249 factor2=0.5 w0=0
X10_7_10_8m m10_7_10_8 p10_7_10_8 growth w0=0
R10_7_10_8p p10_7_10_8 n10_8 2647391.233933647
X10_7_10_8n q10_7_10_8 m10_7_10_8 growth w0=0
R10_7_10_8n q10_7_10_8 n10_8 2647391.233933647
X10_8_10_9p n10_8 m10_8_10_9 n5_3 n10_8 prune eta2=0.5 factor=0.061403890520469843 factor2=0.25 w0=0
X10_8_10_9m m10_8_10_9 p10_8_10_9 growth w0=0
R10_8_10_9p p10_8_10_9 n10_9 2647391.233933647
X10_8_10_9n q10_8_10_9 m10_8_10_9 growth w0=0
R10_8_10_9n q10_8_10_9 n10_9 2647391.233933647
X10_9_11_9p n10_9 m10_9_11_9 n5_3 n10_8 prune eta2=0.5 factor=0.057106019873885805 factor2=0.10355339059327377 w0=0
X10_9_11_9m m10_9_11_9 p10_9_11_9 growth w0=0
R10_9_11_9p p10_9_11_9 n11_9 2647391.233933647
X10_9_11_9n q10_9_11_9 m10_9_11_9 growth w0=0
R10_9_11_9n q10_9_11_9 n11_9 2647391.233933647
X10_9_10_10p n10_9 m10_9_10_10 n5_3 n10_8 prune eta2=0.5 factor=0.055589012967083254 factor2=0.16666666666666666 w0=0
X10_9_10_10m m10_9_10_10 p10_9_10_10 growth w0=0
R10_9_10_10p p10_9_10_10 n10_10 2647391.233933647
X10_9_10_10n q10_9_10_10 m10_9_10_10 growth w0=0
R10_9_10_10n q10_9_10_10 n10_10 2647391.233933647
X10_10_11_10p n10_10 m10_10_11_10 n5_3 n10_8 prune eta2=0.5 factor=0.05237944997294487 factor2=0.12360679774997897 w0=0
X10_10_11_10m m10_10_11_10 p10_10_11_10 growth w0=0
R10_10_11_10p p10_10_11_10 n11_10 2647391.233933647
X10_10_11_10n q10_10_11_10 m10_10_11_10 growth w0=0
R10_10_11_10n q10_10_11_10 n11_10 2647391.233933647
X10_10_10_11p n10_10 m10_10_10_11 n5_3 n10_8 prune eta2=0.5 factor=0.05061250168624366 factor2=0.125 w0=0
X10_10_10_11m m10_10_10_11 p10_10_10_11 growth w0=0
R10_10_10_11p p10_10_10_11 n10_11 2647391.233933647
X10_10_10_11n q10_10_10_11 m10_10_10_11 growth w0=0
R10_10_10_11n q10_10_10_11 n10_11 2647391.233933647
X10_11_11_11p n10_11 m10_11_11_11 n5_3 n10_8 prune eta2=0.5 factor=0.04818181818181819 factor2=0.10811388300841895 w0=0
X10_11_11_11m m10_11_11_11 p10_11_11_11 growth w0=0
R10_11_11_11p p10_11_11_11 n11_11 2647391.233933647
X10_11_11_11n q10_11_11_11 m10_11_11_11 growth w0=0
R10_11_11_11n q10_11_11_11 n11_11 2647391.233933647
X10_11_10_12p n10_11 m10_11_10_12 n5_3 n10_8 prune eta2=0.5 factor=0.046352872670689896 factor2=0.1 w0=0
X10_11_10_12m m10_11_10_12 p10_11_10_12 growth w0=0
R10_11_10_12p p10_11_10_12 n10_12 2647391.233933647
X10_11_10_12n q10_11_10_12 m10_11_10_12 growth w0=0
R10_11_10_12n q10_11_10_12 n10_12 2647391.233933647
X10_12_11_12p n10_12 m10_12_11_12 n5_3 n10_8 prune eta2=0.5 factor=0.044483068841961834 factor2=0.09185604781228413 w0=0
X10_12_11_12m m10_12_11_12 p10_12_11_12 growth w0=0
R10_12_11_12p p10_12_11_12 n11_12 2647391.233933647
X10_12_11_12n q10_12_11_12 m10_12_11_12 growth w0=0
R10_12_11_12n q10_12_11_12 n11_12 2647391.233933647
X10_12_10_13p n10_12 m10_12_10_13 n5_3 n10_8 prune eta2=0.5 factor=0.04269174791531817 factor2=0.08333333333333333 w0=0
X10_12_10_13m m10_12_10_13 p10_12_10_13 growth w0=0
R10_12_10_13p p10_12_10_13 n10_13 2647391.233933647
X10_12_10_13n q10_12_10_13 m10_12_10_13 growth w0=0
R10_12_10_13n q10_12_10_13 n10_13 2647391.233933647
X10_13_11_13p n10_13 m10_13_11_13 n5_3 n10_8 prune eta2=0.5 factor=0.041230673696515945 factor2=0.07882729833832279 w0=0
X10_13_11_13m m10_13_11_13 p10_13_11_13 growth w0=0
R10_13_11_13p p10_13_11_13 n11_13 2647391.233933647
X10_13_11_13n q10_13_11_13 m10_13_11_13 growth w0=0
R10_13_11_13n q10_13_11_13 n11_13 2647391.233933647
X10_13_10_14p n10_13 m10_13_10_14 n5_3 n10_8 prune eta2=0.5 factor=0.03952621497432169 factor2=0.07142857142857142 w0=0
X10_13_10_14m m10_13_10_14 p10_13_10_14 growth w0=0
R10_13_10_14p p10_13_10_14 n10_14 2647391.233933647
X10_13_10_14n q10_13_10_14 m10_13_10_14 growth w0=0
R10_13_10_14n q10_13_10_14 n10_14 2647391.233933647
X10_14_11_14p n10_14 m10_14_11_14 n5_3 n10_8 prune eta2=0.5 factor=0.03836730659074579 factor2=0.06868598013916513 w0=0
X10_14_11_14m m10_14_11_14 p10_14_11_14 growth w0=0
R10_14_11_14p p10_14_11_14 n11_14 2647391.233933647
X10_14_11_14n q10_14_11_14 m10_14_11_14 growth w0=0
R10_14_11_14n q10_14_11_14 n11_14 2647391.233933647
X10_14_10_15p n10_14 m10_14_10_15 n5_3 n10_8 prune eta2=0.5 factor=0.036770921386306 factor2=0.0625 w0=0
X10_14_10_15m m10_14_10_15 p10_14_10_15 growth w0=0
R10_14_10_15p p10_14_10_15 n10_15 2647391.233933647
X10_14_10_15n q10_14_10_15 m10_14_10_15 growth w0=0
R10_14_10_15n q10_14_10_15 n10_15 2647391.233933647
X10_15_11_15p n10_15 m10_15_11_15 n5_3 n10_8 prune eta2=0.5 factor=0.0358387936512999 factor2=0.06071067811865475 w0=0
X10_15_11_15m m10_15_11_15 p10_15_11_15 growth w0=0
R10_15_11_15p p10_15_11_15 n11_15 2647391.233933647
X10_15_11_15n q10_15_11_15 m10_15_11_15 growth w0=0
R10_15_11_15n q10_15_11_15 n11_15 2647391.233933647
X11_1_12_1p n11_1 m11_1_12_1 n5_3 n10_8 prune eta2=0.5 factor=0.06836113812714643 factor2=0.05810696740807447 w0=0
X11_1_12_1m m11_1_12_1 p11_1_12_1 growth w0=0
R11_1_12_1p p11_1_12_1 n12_1 2647391.233933647
X11_1_12_1n q11_1_12_1 m11_1_12_1 growth w0=0
R11_1_12_1n q11_1_12_1 n12_1 2647391.233933647
X11_1_11_2p n11_1 m11_1_11_2 n5_3 n10_8 prune eta2=0.5 factor=0.08204158738844725 factor2=0.06868598013916513 w0=0
X11_1_11_2m m11_1_11_2 p11_1_11_2 growth w0=0
R11_1_11_2p p11_1_11_2 n11_2 2647391.233933647
X11_1_11_2n q11_1_11_2 m11_1_11_2 growth w0=0
R11_1_11_2n q11_1_11_2 n11_2 2647391.233933647
X11_2_12_2p n11_2 m11_2_12_2 n5_3 n10_8 prune eta2=0.5 factor=0.07062262556659839 factor2=0.06485035326051179 w0=0
X11_2_12_2m m11_2_12_2 p11_2_12_2 growth w0=0
R11_2_12_2p p11_2_12_2 n12_2 2647391.233933647
X11_2_12_2n q11_2_12_2 m11_2_12_2 growth w0=0
R11_2_12_2n q11_2_12_2 n12_2 2647391.233933647
X11_2_11_3p n11_2 m11_2_11_3 n5_3 n10_8 prune eta2=0.5 factor=0.08333333333333334 factor2=0.07882729833832279 w0=0
X11_2_11_3m m11_2_11_3 p11_2_11_3 growth w0=0
R11_2_11_3p p11_2_11_3 n11_3 2647391.233933647
X11_2_11_3n q11_2_11_3 m11_2_11_3 growth w0=0
R11_2_11_3n q11_2_11_3 n11_3 2647391.233933647
X11_3_12_3p n11_3 m11_3_12_3 n5_3 n10_8 prune eta2=0.5 factor=0.07142857142857142 factor2=0.07290606514324606 w0=0
X11_3_12_3m m11_3_12_3 p11_3_12_3 growth w0=0
R11_3_12_3p p11_3_12_3 n12_3 2647391.233933647
X11_3_12_3n q11_3_12_3 m11_3_12_3 growth w0=0
R11_3_12_3n q11_3_12_3 n12_3 2647391.233933647
X11_3_11_4p n11_3 m11_3_11_4 n5_3 n10_8 prune eta2=0.5 factor=0.08204158738844725 factor2=0.09185604781228413 w0=0
X11_3_11_4m m11_3_11_4 p11_3_11_4 growth w0=0
R11_3_11_4p p11_3_11_4 n11_4 2647391.233933647
X11_3_11_4n q11_3_11_4 m11_3_11_4 growth w0=0
R11_3_11_4n q11_3_11_4 n11_4 2647391.233933647
X11_4_12_4p n11_4 m11_4_12_4 n5_3 n10_8 prune eta2=0.5 factor=0.07062262556659839 factor2=0.08223479893420056 w0=0
X11_4_12_4m m11_4_12_4 p11_4_12_4 growth w0=0
R11_4_12_4p p11_4_12_4 n12_4 2647391.233933647
X11_4_12_4n q11_4_12_4 m11_4_12_4 growth w0=0
R11_4_12_4n q11_4_12_4 n12_4 2647391.233933647
X11_4_11_5p n11_4 m11_4_11_5 n5_3 n10_8 prune eta2=0.5 factor=0.07850305921009322 factor2=0.10811388300841895 w0=0
X11_4_11_5m m11_4_11_5 p11_4_11_5 growth w0=0
R11_4_11_5p p11_4_11_5 n11_5 2647391.233933647
X11_4_11_5n q11_4_11_5 m11_4_11_5 growth w0=0
R11_4_11_5n q11_4_11_5 n11_5 2647391.233933647
X11_5_12_5p n11_5 m11_5_12_5 n5_3 n10_8 prune eta2=0.5 factor=0.06836113812714643 factor2=0.09186238471187141 w0=0
X11_5_12_5m m11_5_12_5 p11_5_12_5 growth w0=0
R11_5_12_5p p11_5_12_5 n12_5 2647391.233933647
X11_5_12_5n q11_5_12_5 m11_5_12_5 growth w0=0
R11_5_12_5n q11_5_12_5 n12_5 2647391.233933647
X11_5_11_6p n11_5 m11_5_11_6 n5_3 n10_8 prune eta2=0.5 factor=0.07351474761552217 factor2=0.12360679774997897 w0=0
X11_5_11_6m m11_5_11_6 p11_5_11_6 growth w0=0
R11_5_11_6p p11_5_11_6 n11_6 2647391.233933647
X11_5_11_6n q11_5_11_6 m11_5_11_6 growth w0=0
R11_5_11_6n q11_5_11_6 n11_6 2647391.233933647
X11_6_12_6p n11_6 m11_6_12_6 n5_3 n10_8 prune eta2=0.5 factor=0.0650370919360487 factor2=0.09795145311140303 w0=0
X11_6_12_6m m11_6_12_6 p11_6_12_6 growth w0=0
R11_6_12_6p p11_6_12_6 n12_6 2647391.233933647
X11_6_12_6n q11_6_12_6 m11_6_12_6 growth w0=0
R11_6_12_6n q11_6_12_6 n12_6 2647391.233933647
X11_6_11_7p n11_7 m11_6_11_7 n5_3 n10_8 prune eta2=0.5 factor=0.07351474761552217 factor2=0.12360679774997897 w0=0
X11_6_11_7m m11_6_11_7 p11_6_11_7 growth w0=0
R11_6_11_7p p11_6_11_7 n11_6 6006.050391399449
X11_6_11_7n q11_6_11_7 m11_6_11_7 growth w0=0
R11_6_11_7n q11_6_11_7 n11_6 3004981.5674761934
X11_7_12_7p n11_7 m11_7_12_7 n5_3 n10_8 prune eta2=0.5 factor=0.06111569205258361 factor2=0.09270509831248422 w0=0
X11_7_12_7m m11_7_12_7 p11_7_12_7 growth w0=0
R11_7_12_7p p11_7_12_7 n12_7 2647391.233933647
X11_7_12_7n q11_7_12_7 m11_7_12_7 growth w0=0
R11_7_12_7n q11_7_12_7 n12_7 2647391.233933647
X11_7_11_8p n11_8 m11_7_11_8 n5_3 n10_8 prune eta2=0.5 factor=0.06791929637138439 factor2=0.10355339059327377 w0=0
X11_7_11_8m m11_7_11_8 p11_7_11_8 growth w0=0
R11_7_11_8p p11_7_11_8 n11_7 6006.050391399449
X11_7_11_8n q11_7_11_8 m11_7_11_8 growth w0=0
R11_7_11_8n q11_7_11_8 n11_7 3004981.5674761934
X11_8_12_8p n12_8 m11_8_12_8 n5_3 n10_8 prune eta2=0.5 factor=0.06233425249805272 factor2=0.0 w0=0
X11_8_12_8m m11_8_12_8 p11_8_12_8 growth w0=0
R11_8_12_8p p11_8_12_8 n11_8 6006.050391399449
X11_8_12_8n q11_8_12_8 m11_8_12_8 growth w0=0
R11_8_12_8n q11_8_12_8 n11_8 3004981.5674761934
X11_8_11_9p n11_8 m11_8_11_9 n5_3 n10_8 prune eta2=0.5 factor=0.057106019873885805 factor2=0.10355339059327377 w0=0
X11_8_11_9m m11_8_11_9 p11_8_11_9 growth w0=0
R11_8_11_9p p11_8_11_9 n11_9 2647391.233933647
X11_8_11_9n q11_8_11_9 m11_8_11_9 growth w0=0
R11_8_11_9n q11_8_11_9 n11_9 2647391.233933647
X11_9_12_9p n11_9 m11_9_12_9 n5_3 n10_8 prune eta2=0.5 factor=0.05295504832429591 factor2=0.09270509831248422 w0=0
X11_9_12_9m m11_9_12_9 p11_9_12_9 growth w0=0
R11_9_12_9p p11_9_12_9 n12_9 2647391.233933647
X11_9_12_9n q11_9_12_9 m11_9_12_9 growth w0=0
R11_9_12_9n q11_9_12_9 n12_9 2647391.233933647
X11_9_11_10p n11_9 m11_9_11_10 n5_3 n10_8 prune eta2=0.5 factor=0.05237944997294487 factor2=0.12360679774997897 w0=0
X11_9_11_10m m11_9_11_10 p11_9_11_10 growth w0=0
R11_9_11_10p p11_9_11_10 n11_10 2647391.233933647
X11_9_11_10n q11_9_11_10 m11_9_11_10 growth w0=0
R11_9_11_10n q11_9_11_10 n11_10 2647391.233933647
X11_10_12_10p n11_10 m11_10_12_10 n5_3 n10_8 prune eta2=0.5 factor=0.04915037704314248 factor2=0.09795145311140303 w0=0
X11_10_12_10m m11_10_12_10 p11_10_12_10 growth w0=0
R11_10_12_10p p11_10_12_10 n12_10 2647391.233933647
X11_10_12_10n q11_10_12_10 m11_10_12_10 growth w0=0
R11_10_12_10n q11_10_12_10 n12_10 2647391.233933647
X11_10_11_11p n11_10 m11_10_11_11 n5_3 n10_8 prune eta2=0.5 factor=0.04818181818181819 factor2=0.10811388300841895 w0=0
X11_10_11_11m m11_10_11_11 p11_10_11_11 growth w0=0
R11_10_11_11p p11_10_11_11 n11_11 2647391.233933647
X11_10_11_11n q11_10_11_11 m11_10_11_11 growth w0=0
R11_10_11_11n q11_10_11_11 n11_11 2647391.233933647
X11_11_12_11p n11_11 m11_11_12_11 n5_3 n10_8 prune eta2=0.5 factor=0.04565492641941206 factor2=0.09186238471187141 w0=0
X11_11_12_11m m11_11_12_11 p11_11_12_11 growth w0=0
R11_11_12_11p p11_11_12_11 n12_11 2647391.233933647
X11_11_12_11n q11_11_12_11 m11_11_12_11 growth w0=0
R11_11_12_11n q11_11_12_11 n12_11 2647391.233933647
X11_11_11_12p n11_11 m11_11_11_12 n5_3 n10_8 prune eta2=0.5 factor=0.044483068841961834 factor2=0.09185604781228413 w0=0
X11_11_11_12m m11_11_11_12 p11_11_11_12 growth w0=0
R11_11_11_12p p11_11_11_12 n11_12 2647391.233933647
X11_11_11_12n q11_11_11_12 m11_11_11_12 growth w0=0
R11_11_11_12n q11_11_11_12 n11_12 2647391.233933647
X11_12_12_12p n11_12 m11_12_12_12 n5_3 n10_8 prune eta2=0.5 factor=0.04248778570023313 factor2=0.08223479893420056 w0=0
X11_12_12_12m m11_12_12_12 p11_12_12_12 growth w0=0
R11_12_12_12p p11_12_12_12 n12_12 2647391.233933647
X11_12_12_12n q11_12_12_12 m11_12_12_12 growth w0=0
R11_12_12_12n q11_12_12_12 n12_12 2647391.233933647
X11_12_11_13p n11_12 m11_12_11_13 n5_3 n10_8 prune eta2=0.5 factor=0.041230673696515945 factor2=0.07882729833832279 w0=0
X11_12_11_13m m11_12_11_13 p11_12_11_13 growth w0=0
R11_12_11_13p p11_12_11_13 n11_13 2647391.233933647
X11_12_11_13n q11_12_11_13 m11_12_11_13 growth w0=0
R11_12_11_13n q11_12_11_13 n11_13 2647391.233933647
X11_13_12_13p n11_13 m11_13_12_13 n5_3 n10_8 prune eta2=0.5 factor=0.03963864221055818 factor2=0.07290606514324606 w0=0
X11_13_12_13m m11_13_12_13 p11_13_12_13 growth w0=0
R11_13_12_13p p11_13_12_13 n12_13 2647391.233933647
X11_13_12_13n q11_13_12_13 m11_13_12_13 growth w0=0
R11_13_12_13n q11_13_12_13 n12_13 2647391.233933647
X11_13_11_14p n11_13 m11_13_11_14 n5_3 n10_8 prune eta2=0.5 factor=0.03836730659074579 factor2=0.06868598013916513 w0=0
X11_13_11_14m m11_13_11_14 p11_13_11_14 growth w0=0
R11_13_11_14p p11_13_11_14 n11_14 2647391.233933647
X11_13_11_14n q11_13_11_14 m11_13_11_14 growth w0=0
R11_13_11_14n q11_13_11_14 n11_14 2647391.233933647
X11_14_12_14p n11_14 m11_14_12_14 n5_3 n10_8 prune eta2=0.5 factor=0.037083147431982905 factor2=0.06485035326051179 w0=0
X11_14_12_14m m11_14_12_14 p11_14_12_14 growth w0=0
R11_14_12_14p p11_14_12_14 n12_14 2647391.233933647
X11_14_12_14n q11_14_12_14 m11_14_12_14 growth w0=0
R11_14_12_14n q11_14_12_14 n12_14 2647391.233933647
X11_14_11_15p n11_14 m11_14_11_15 n5_3 n10_8 prune eta2=0.5 factor=0.0358387936512999 factor2=0.06071067811865475 w0=0
X11_14_11_15m m11_14_11_15 p11_14_11_15 growth w0=0
R11_14_11_15p p11_14_11_15 n11_15 2647391.233933647
X11_14_11_15n q11_14_11_15 m11_14_11_15 growth w0=0
R11_14_11_15n q11_14_11_15 n11_15 2647391.233933647
X11_15_12_15p n11_15 m11_15_12_15 n5_3 n10_8 prune eta2=0.5 factor=0.03479178537740124 factor2=0.05810696740807447 w0=0
X11_15_12_15m m11_15_12_15 p11_15_12_15 growth w0=0
R11_15_12_15p p11_15_12_15 n12_15 2647391.233933647
X11_15_12_15n q11_15_12_15 m11_15_12_15 growth w0=0
R11_15_12_15n q11_15_12_15 n12_15 2647391.233933647
X12_1_13_1p n12_1 m12_1_13_1 n5_3 n10_8 prune eta2=0.5 factor=0.06043810964594869 factor2=0.0550313854843489 w0=0
X12_1_13_1m m12_1_13_1 p12_1_13_1 growth w0=0
R12_1_13_1p p12_1_13_1 n13_1 2647391.233933647
X12_1_13_1n q12_1_13_1 m12_1_13_1 growth w0=0
R12_1_13_1n q12_1_13_1 n13_1 2647391.233933647
X12_1_12_2p n12_1 m12_1_12_2 n5_3 n10_8 prune eta2=0.5 factor=0.07062262556659839 factor2=0.06485035326051179 w0=0
X12_1_12_2m m12_1_12_2 p12_1_12_2 growth w0=0
R12_1_12_2p p12_1_12_2 n12_2 2647391.233933647
X12_1_12_2n q12_1_12_2 m12_1_12_2 growth w0=0
R12_1_12_2n q12_1_12_2 n12_2 2647391.233933647
X12_2_13_2p n12_2 m12_2_13_2 n5_3 n10_8 prune eta2=0.5 factor=0.06196452110886949 factor2=0.06054155685984179 w0=0
X12_2_13_2m m12_2_13_2 p12_2_13_2 growth w0=0
R12_2_13_2p p12_2_13_2 n13_2 2647391.233933647
X12_2_13_2n q12_2_13_2 m12_2_13_2 growth w0=0
R12_2_13_2n q12_2_13_2 n13_2 2647391.233933647
X12_2_12_3p n12_2 m12_2_12_3 n5_3 n10_8 prune eta2=0.5 factor=0.07142857142857142 factor2=0.07290606514324606 w0=0
X12_2_12_3m m12_2_12_3 p12_2_12_3 growth w0=0
R12_2_12_3p p12_2_12_3 n12_3 2647391.233933647
X12_2_12_3n q12_2_12_3 m12_2_12_3 growth w0=0
R12_2_12_3n q12_2_12_3 n12_3 2647391.233933647
X12_3_13_3p n12_3 m12_3_13_3 n5_3 n10_8 prune eta2=0.5 factor=0.0625 factor2=0.06673774899296092 w0=0
X12_3_13_3m m12_3_13_3 p12_3_13_3 growth w0=0
R12_3_13_3p p12_3_13_3 n13_3 2647391.233933647
X12_3_13_3n q12_3_13_3 m12_3_13_3 growth w0=0
R12_3_13_3n q12_3_13_3 n13_3 2647391.233933647
X12_3_12_4p n12_3 m12_3_12_4 n5_3 n10_8 prune eta2=0.5 factor=0.07062262556659839 factor2=0.08223479893420056 w0=0
X12_3_12_4m m12_3_12_4 p12_3_12_4 growth w0=0
R12_3_12_4p p12_3_12_4 n12_4 2647391.233933647
X12_3_12_4n q12_3_12_4 m12_3_12_4 growth w0=0
R12_3_12_4n q12_3_12_4 n12_4 2647391.233933647
X12_4_13_4p n12_4 m12_4_13_4 n5_3 n10_8 prune eta2=0.5 factor=0.06196452110886949 factor2=0.07333333333333333 w0=0
X12_4_13_4m m12_4_13_4 p12_4_13_4 growth w0=0
R12_4_13_4p p12_4_13_4 n13_4 2647391.233933647
X12_4_13_4n q12_4_13_4 m12_4_13_4 growth w0=0
R12_4_13_4n q12_4_13_4 n13_4 2647391.233933647
X12_4_12_5p n12_4 m12_4_12_5 n5_3 n10_8 prune eta2=0.5 factor=0.06836113812714643 factor2=0.09186238471187141 w0=0
X12_4_12_5m m12_4_12_5 p12_4_12_5 growth w0=0
R12_4_12_5p p12_4_12_5 n12_5 2647391.233933647
X12_4_12_5n q12_4_12_5 m12_4_12_5 growth w0=0
R12_4_12_5n q12_4_12_5 n12_5 2647391.233933647
X12_5_13_5p n12_5 m12_5_13_5 n5_3 n10_8 prune eta2=0.5 factor=0.06043810964594869 factor2=0.07947648742939425 w0=0
X12_5_13_5m m12_5_13_5 p12_5_13_5 growth w0=0
R12_5_13_5p p12_5_13_5 n13_5 2647391.233933647
X12_5_13_5n q12_5_13_5 m12_5_13_5 growth w0=0
R12_5_13_5n q12_5_13_5 n13_5 2647391.233933647
X12_5_12_6p n12_5 m12_5_12_6 n5_3 n10_8 prune eta2=0.5 factor=0.0650370919360487 factor2=0.09795145311140303 w0=0
X12_5_12_6m m12_5_12_6 p12_5_12_6 growth w0=0
R12_5_12_6p p12_5_12_6 n12_6 2647391.233933647
X12_5_12_6n q12_5_12_6 m12_5_12_6 growth w0=0
R12_5_12_6n q12_5_12_6 n12_6 2647391.233933647
X12_6_13_6p n12_6 m12_6_13_6 n5_3 n10_8 prune eta2=0.5 factor=0.058130165845768654 factor2=0.083511258828974 w0=0
X12_6_13_6m m12_6_13_6 p12_6_13_6 growth w0=0
R12_6_13_6p p12_6_13_6 n13_6 2647391.233933647
X12_6_13_6n q12_6_13_6 m12_6_13_6 growth w0=0
R12_6_13_6n q12_6_13_6 n13_6 2647391.233933647
X12_6_12_7p n12_6 m12_6_12_7 n5_3 n10_8 prune eta2=0.5 factor=0.06111569205258361 factor2=0.09270509831248422 w0=0
X12_6_12_7m m12_6_12_7 p12_6_12_7 growth w0=0
R12_6_12_7p p12_6_12_7 n12_7 2647391.233933647
X12_6_12_7n q12_6_12_7 m12_6_12_7 growth w0=0
R12_6_12_7n q12_6_12_7 n12_7 2647391.233933647
X12_7_13_7p n12_7 m12_7_13_7 n5_3 n10_8 prune eta2=0.5 factor=0.055308222158221995 factor2=0.08408857567321473 w0=0
X12_7_13_7m m12_7_13_7 p12_7_13_7 growth w0=0
R12_7_13_7p p12_7_13_7 n13_7 2647391.233933647
X12_7_13_7n q12_7_13_7 m12_7_13_7 growth w0=0
R12_7_13_7n q12_7_13_7 n13_7 2647391.233933647
X12_7_12_8p n12_7 m12_7_12_8 n5_3 n10_8 prune eta2=0.5 factor=0.056996329751060046 factor2=0.08333333333333333 w0=0
X12_7_12_8m m12_7_12_8 p12_7_12_8 growth w0=0
R12_7_12_8p p12_7_12_8 n12_8 2647391.233933647
X12_7_12_8n q12_7_12_8 m12_7_12_8 growth w0=0
R12_7_12_8n q12_7_12_8 n12_8 2647391.233933647
X12_8_13_8p n13_8 m12_8_13_8 n5_3 n10_8 prune eta2=0.5 factor=0.056996329751060046 factor2=0.08333333333333333 w0=0
X12_8_13_8m m12_8_13_8 p12_8_13_8 growth w0=0
R12_8_13_8p p12_8_13_8 n12_8 6006.050391399449
X12_8_13_8n q12_8_13_8 m12_8_13_8 growth w0=0
R12_8_13_8n q12_8_13_8 n12_8 3004981.5674761934
X12_8_12_9p n12_8 m12_8_12_9 n5_3 n10_8 prune eta2=0.5 factor=0.05295504832429591 factor2=0.09270509831248422 w0=0
X12_8_12_9m m12_8_12_9 p12_8_12_9 growth w0=0
R12_8_12_9p p12_8_12_9 n12_9 2647391.233933647
X12_8_12_9n q12_8_12_9 m12_8_12_9 growth w0=0
R12_8_12_9n q12_8_12_9 n12_9 2647391.233933647
X12_9_13_9p n12_9 m12_9_13_9 n5_3 n10_8 prune eta2=0.5 factor=0.049090909090909095 factor2=0.08408857567321473 w0=0
X12_9_13_9m m12_9_13_9 p12_9_13_9 growth w0=0
R12_9_13_9p p12_9_13_9 n13_9 2647391.233933647
X12_9_13_9n q12_9_13_9 m12_9_13_9 growth w0=0
R12_9_13_9n q12_9_13_9 n13_9 2647391.233933647
X12_9_12_10p n12_9 m12_9_12_10 n5_3 n10_8 prune eta2=0.5 factor=0.04915037704314248 factor2=0.09795145311140303 w0=0
X12_9_12_10m m12_9_12_10 p12_9_12_10 growth w0=0
R12_9_12_10p p12_9_12_10 n12_10 2647391.233933647
X12_9_12_10n q12_9_12_10 m12_9_12_10 growth w0=0
R12_9_12_10n q12_9_12_10 n12_10 2647391.233933647
X12_10_13_10p n12_10 m12_10_13_10 n5_3 n10_8 prune eta2=0.5 factor=0.04603538413957382 factor2=0.083511258828974 w0=0
X12_10_13_10m m12_10_13_10 p12_10_13_10 growth w0=0
R12_10_13_10p p12_10_13_10 n13_10 2647391.233933647
X12_10_13_10n q12_10_13_10 m12_10_13_10 growth w0=0
R12_10_13_10n q12_10_13_10 n13_10 2647391.233933647
X12_10_12_11p n12_10 m12_10_12_11 n5_3 n10_8 prune eta2=0.5 factor=0.04565492641941206 factor2=0.09186238471187141 w0=0
X12_10_12_11m m12_10_12_11 p12_10_12_11 growth w0=0
R12_10_12_11p p12_10_12_11 n12_11 2647391.233933647
X12_10_12_11n q12_10_12_11 m12_10_12_11 growth w0=0
R12_10_12_11n q12_10_12_11 n12_11 2647391.233933647
X12_11_13_11p n12_11 m12_11_13_11 n5_3 n10_8 prune eta2=0.5 factor=0.04314297354398153 factor2=0.07947648742939425 w0=0
X12_11_13_11m m12_11_13_11 p12_11_13_11 growth w0=0
R12_11_13_11p p12_11_13_11 n13_11 2647391.233933647
X12_11_13_11n q12_11_13_11 m12_11_13_11 growth w0=0
R12_11_13_11n q12_11_13_11 n13_11 2647391.233933647
X12_11_12_12p n12_11 m12_11_12_12 n5_3 n10_8 prune eta2=0.5 factor=0.04248778570023313 factor2=0.08223479893420056 w0=0
X12_11_12_12m m12_11_12_12 p12_11_12_12 growth w0=0
R12_11_12_12p p12_11_12_12 n12_12 2647391.233933647
X12_11_12_12n q12_11_12_12 m12_11_12_12 growth w0=0
R12_11_12_12n q12_11_12_12 n12_12 2647391.233933647
X12_12_13_12p n12_12 m12_12_13_12 n5_3 n10_8 prune eta2=0.5 factor=0.04045411806885109 factor2=0.07333333333333333 w0=0
X12_12_13_12m m12_12_13_12 p12_12_13_12 growth w0=0
R12_12_13_12p p12_12_13_12 n13_12 2647391.233933647
X12_12_13_12n q12_12_13_12 m12_12_13_12 growth w0=0
R12_12_13_12n q12_12_13_12 n13_12 2647391.233933647
X12_12_12_13p n12_12 m12_12_12_13 n5_3 n10_8 prune eta2=0.5 factor=0.03963864221055818 factor2=0.07290606514324606 w0=0
X12_12_12_13m m12_12_12_13 p12_12_12_13 growth w0=0
R12_12_12_13p p12_12_12_13 n12_13 2647391.233933647
X12_12_12_13n q12_12_12_13 m12_12_12_13 growth w0=0
R12_12_12_13n q12_12_12_13 n12_13 2647391.233933647
X12_13_13_13p n12_13 m12_13_13_13 n5_3 n10_8 prune eta2=0.5 factor=0.03798209519820627 factor2=0.06673774899296092 w0=0
X12_13_13_13m m12_13_13_13 p12_13_13_13 growth w0=0
R12_13_13_13p p12_13_13_13 n13_13 2647391.233933647
X12_13_13_13n q12_13_13_13 m12_13_13_13 growth w0=0
R12_13_13_13n q12_13_13_13 n13_13 2647391.233933647
X12_13_12_14p n12_13 m12_13_12_14 n5_3 n10_8 prune eta2=0.5 factor=0.037083147431982905 factor2=0.06485035326051179 w0=0
X12_13_12_14m m12_13_12_14 p12_13_12_14 growth w0=0
R12_13_12_14p p12_13_12_14 n12_14 2647391.233933647
X12_13_12_14n q12_13_12_14 m12_13_12_14 growth w0=0
R12_13_12_14n q12_13_12_14 n12_14 2647391.233933647
X12_14_13_14p n12_14 m12_14_13_14 n5_3 n10_8 prune eta2=0.5 factor=0.03572391022599795 factor2=0.06054155685984179 w0=0
X12_14_13_14m m12_14_13_14 p12_14_13_14 growth w0=0
R12_14_13_14p p12_14_13_14 n13_14 2647391.233933647
X12_14_13_14n q12_14_13_14 m12_14_13_14 growth w0=0
R12_14_13_14n q12_14_13_14 n13_14 2647391.233933647
X12_14_12_15p n12_14 m12_14_12_15 n5_3 n10_8 prune eta2=0.5 factor=0.03479178537740124 factor2=0.05810696740807447 w0=0
X12_14_12_15m m12_14_12_15 p12_14_12_15 growth w0=0
R12_14_12_15p p12_14_12_15 n12_15 2647391.233933647
X12_14_12_15n q12_14_12_15 m12_14_12_15 growth w0=0
R12_14_12_15n q12_14_12_15 n12_15 2647391.233933647
X12_15_13_15p n12_15 m12_15_13_15 n5_3 n10_8 prune eta2=0.5 factor=0.03366773854980592 factor2=0.0550313854843489 w0=0
X12_15_13_15m m12_15_13_15 p12_15_13_15 growth w0=0
R12_15_13_15p p12_15_13_15 n13_15 2647391.233933647
X12_15_13_15n q12_15_13_15 m12_15_13_15 growth w0=0
R12_15_13_15n q12_15_13_15 n13_15 2647391.233933647
X13_1_14_1p n13_1 m13_1_14_1 n5_3 n10_8 prune eta2=0.5 factor=0.054106245026998005 factor2=0.05177857243343889 w0=0
X13_1_14_1m m13_1_14_1 p13_1_14_1 growth w0=0
R13_1_14_1p p13_1_14_1 n14_1 2647391.233933647
X13_1_14_1n q13_1_14_1 m13_1_14_1 growth w0=0
R13_1_14_1n q13_1_14_1 n14_1 2647391.233933647
X13_1_13_2p n13_1 m13_1_13_2 n5_3 n10_8 prune eta2=0.5 factor=0.06196452110886949 factor2=0.06054155685984179 w0=0
X13_1_13_2m m13_1_13_2 p13_1_13_2 growth w0=0
R13_1_13_2p p13_1_13_2 n13_2 2647391.233933647
X13_1_13_2n q13_1_13_2 m13_1_13_2 growth w0=0
R13_1_13_2n q13_1_13_2 n13_2 2647391.233933647
X13_2_14_2p n13_2 m13_2_14_2 n5_3 n10_8 prune eta2=0.5 factor=0.05518217762500037 factor2=0.056209072859076725 w0=0
X13_2_14_2m m13_2_14_2 p13_2_14_2 growth w0=0
R13_2_14_2p p13_2_14_2 n14_2 2647391.233933647
X13_2_14_2n q13_2_14_2 m13_2_14_2 growth w0=0
R13_2_14_2n q13_2_14_2 n14_2 2647391.233933647
X13_2_13_3p n13_2 m13_2_13_3 n5_3 n10_8 prune eta2=0.5 factor=0.0625 factor2=0.06673774899296092 w0=0
X13_2_13_3m m13_2_13_3 p13_2_13_3 growth w0=0
R13_2_13_3p p13_2_13_3 n13_3 2647391.233933647
X13_2_13_3n q13_2_13_3 m13_2_13_3 growth w0=0
R13_2_13_3n q13_2_13_3 n13_3 2647391.233933647
X13_3_14_3p n13_3 m13_3_14_3 n5_3 n10_8 prune eta2=0.5 factor=0.05555555555555556 factor2=0.06094987706860226 w0=0
X13_3_14_3m m13_3_14_3 p13_3_14_3 growth w0=0
R13_3_14_3p p13_3_14_3 n14_3 2647391.233933647
X13_3_14_3n q13_3_14_3 m13_3_14_3 growth w0=0
R13_3_14_3n q13_3_14_3 n14_3 2647391.233933647
X13_3_13_4p n13_3 m13_3_13_4 n5_3 n10_8 prune eta2=0.5 factor=0.06196452110886949 factor2=0.07333333333333333 w0=0
X13_3_13_4m m13_3_13_4 p13_3_13_4 growth w0=0
R13_3_13_4p p13_3_13_4 n13_4 2647391.233933647
X13_3_13_4n q13_3_13_4 m13_3_13_4 growth w0=0
R13_3_13_4n q13_3_13_4 n13_4 2647391.233933647
X13_4_14_4p n13_4 m13_4_14_4 n5_3 n10_8 prune eta2=0.5 factor=0.05518217762500037 factor2=0.0657217333597715 w0=0
X13_4_14_4m m13_4_14_4 p13_4_14_4 growth w0=0
R13_4_14_4p p13_4_14_4 n14_4 2647391.233933647
X13_4_14_4n q13_4_14_4 m13_4_14_4 growth w0=0
R13_4_14_4n q13_4_14_4 n14_4 2647391.233933647
X13_4_13_5p n13_4 m13_4_13_5 n5_3 n10_8 prune eta2=0.5 factor=0.06043810964594869 factor2=0.07947648742939425 w0=0
X13_4_13_5m m13_4_13_5 p13_4_13_5 growth w0=0
R13_4_13_5p p13_4_13_5 n13_5 2647391.233933647
X13_4_13_5n q13_4_13_5 m13_4_13_5 growth w0=0
R13_4_13_5n q13_4_13_5 n13_5 2647391.233933647
X13_5_14_5p n13_5 m13_5_14_5 n5_3 n10_8 prune eta2=0.5 factor=0.054106245026998005 factor2=0.06999999999999999 w0=0
X13_5_14_5m m13_5_14_5 p13_5_14_5 growth w0=0
R13_5_14_5p p13_5_14_5 n14_5 2647391.233933647
X13_5_14_5n q13_5_14_5 m13_5_14_5 growth w0=0
R13_5_14_5n q13_5_14_5 n14_5 2647391.233933647
X13_5_13_6p n13_5 m13_5_13_6 n5_3 n10_8 prune eta2=0.5 factor=0.058130165845768654 factor2=0.083511258828974 w0=0
X13_5_13_6m m13_5_13_6 p13_5_13_6 growth w0=0
R13_5_13_6p p13_5_13_6 n13_6 2647391.233933647
X13_5_13_6n q13_5_13_6 m13_5_13_6 growth w0=0
R13_5_13_6n q13_5_13_6 n13_6 2647391.233933647
X13_6_14_6p n13_6 m13_6_14_6 n5_3 n10_8 prune eta2=0.5 factor=0.052446720666042994 factor2=0.07309759905262272 w0=0
X13_6_14_6m m13_6_14_6 p13_6_14_6 growth w0=0
R13_6_14_6p p13_6_14_6 n14_6 2647391.233933647
X13_6_14_6n q13_6_14_6 m13_6_14_6 growth w0=0
R13_6_14_6n q13_6_14_6 n14_6 2647391.233933647
X13_6_13_7p n13_6 m13_6_13_7 n5_3 n10_8 prune eta2=0.5 factor=0.055308222158221995 factor2=0.08408857567321473 w0=0
X13_6_13_7m m13_6_13_7 p13_6_13_7 growth w0=0
R13_6_13_7p p13_6_13_7 n13_7 2647391.233933647
X13_6_13_7n q13_6_13_7 m13_6_13_7 growth w0=0
R13_6_13_7n q13_6_13_7 n13_7 2647391.233933647
X13_7_14_7p n13_7 m13_7_14_7 n5_3 n10_8 prune eta2=0.5 factor=0.05036398877740481 factor2=0.07463303884748085 w0=0
X13_7_14_7m m13_7_14_7 p13_7_14_7 growth w0=0
R13_7_14_7p p13_7_14_7 n14_7 2647391.233933647
X13_7_14_7n q13_7_14_7 m13_7_14_7 growth w0=0
R13_7_14_7n q13_7_14_7 n14_7 2647391.233933647
X13_7_13_8p n13_7 m13_7_13_8 n5_3 n10_8 prune eta2=0.5 factor=0.052227794293251445 factor2=0.08333333333333334 w0=0
X13_7_13_8m m13_7_13_8 p13_7_13_8 growth w0=0
R13_7_13_8p p13_7_13_8 n13_8 2647391.233933647
X13_7_13_8n q13_7_13_8 m13_7_13_8 growth w0=0
R13_7_13_8n q13_7_13_8 n13_8 2647391.233933647
X13_8_14_8p n14_8 m13_8_14_8 n5_3 n10_8 prune eta2=0.5 factor=0.052227794293251445 factor2=0.08333333333333334 w0=0
X13_8_14_8m m13_8_14_8 p13_8_14_8 growth w0=0
R13_8_14_8p p13_8_14_8 n13_8 6006.050391399449
X13_8_14_8n q13_8_14_8 m13_8_14_8 growth w0=0
R13_8_14_8n q13_8_14_8 n13_8 3004981.5674761934
X13_8_13_9p n13_8 m13_8_13_9 n5_3 n10_8 prune eta2=0.5 factor=0.049090909090909095 factor2=0.08408857567321473 w0=0
X13_8_13_9m m13_8_13_9 p13_8_13_9 growth w0=0
R13_8_13_9p p13_8_13_9 n13_9 2647391.233933647
X13_8_13_9n q13_8_13_9 m13_8_13_9 growth w0=0
R13_8_13_9n q13_8_13_9 n13_9 2647391.233933647
X13_9_14_9p n13_9 m13_9_14_9 n5_3 n10_8 prune eta2=0.5 factor=0.04556802174054626 factor2=0.07463303884748085 w0=0
X13_9_14_9m m13_9_14_9 p13_9_14_9 growth w0=0
R13_9_14_9p p13_9_14_9 n14_9 2647391.233933647
X13_9_14_9n q13_9_14_9 m13_9_14_9 growth w0=0
R13_9_14_9n q13_9_14_9 n14_9 2647391.233933647
X13_9_13_10p n13_9 m13_9_13_10 n5_3 n10_8 prune eta2=0.5 factor=0.04603538413957382 factor2=0.083511258828974 w0=0
X13_9_13_10m m13_9_13_10 p13_9_13_10 growth w0=0
R13_9_13_10p p13_9_13_10 n13_10 2647391.233933647
X13_9_13_10n q13_9_13_10 m13_9_13_10 growth w0=0
R13_9_13_10n q13_9_13_10 n13_10 2647391.233933647
X13_10_14_10p n13_10 m13_10_14_10 n5_3 n10_8 prune eta2=0.5 factor=0.04310804534549201 factor2=0.07309759905262272 w0=0
X13_10_14_10m m13_10_14_10 p13_10_14_10 growth w0=0
R13_10_14_10p p13_10_14_10 n14_10 2647391.233933647
X13_10_14_10n q13_10_14_10 m13_10_14_10 growth w0=0
R13_10_14_10n q13_10_14_10 n14_10 2647391.233933647
X13_10_13_11p n13_10 m13_10_13_11 n5_3 n10_8 prune eta2=0.5 factor=0.04314297354398153 factor2=0.07947648742939425 w0=0
X13_10_13_11m m13_10_13_11 p13_10_13_11 growth w0=0
R13_10_13_11p p13_10_13_11 n13_11 2647391.233933647
X13_10_13_11n q13_10_13_11 m13_10_13_11 growth w0=0
R13_10_13_11n q13_10_13_11 n13_11 2647391.233933647
X13_11_14_11p n13_11 m13_11_14_11 n5_3 n10_8 prune eta2=0.5 factor=0.040718524069301085 factor2=0.06999999999999999 w0=0
X13_11_14_11m m13_11_14_11 p13_11_14_11 growth w0=0
R13_11_14_11p p13_11_14_11 n14_11 2647391.233933647
X13_11_14_11n q13_11_14_11 m13_11_14_11 growth w0=0
R13_11_14_11n q13_11_14_11 n14_11 2647391.233933647
X13_11_13_12p n13_11 m13_11_13_12 n5_3 n10_8 prune eta2=0.5 factor=0.04045411806885109 factor2=0.07333333333333333 w0=0
X13_11_13_12m m13_11_13_12 p13_11_13_12 growth w0=0
R13_11_13_12p p13_11_13_12 n13_12 2647391.233933647
X13_11_13_12n q13_11_13_12 m13_11_13_12 growth w0=0
R13_11_13_12n q13_11_13_12 n13_12 2647391.233933647
X13_12_14_12p n13_12 m13_12_14_12 n5_3 n10_8 prune eta2=0.5 factor=0.03844556921425108 factor2=0.0657217333597715 w0=0
X13_12_14_12m m13_12_14_12 p13_12_14_12 growth w0=0
R13_12_14_12p p13_12_14_12 n14_12 2647391.233933647
X13_12_14_12n q13_12_14_12 m13_12_14_12 growth w0=0
R13_12_14_12n q13_12_14_12 n14_12 2647391.233933647
X13_12_13_13p n13_12 m13_12_13_13 n5_3 n10_8 prune eta2=0.5 factor=0.03798209519820627 factor2=0.06673774899296092 w0=0
X13_12_13_13m m13_12_13_13 p13_12_13_13 growth w0=0
R13_12_13_13p p13_12_13_13 n13_13 2647391.233933647
X13_12_13_13n q13_12_13_13 m13_12_13_13 growth w0=0
R13_12_13_13n q13_12_13_13 n13_13 2647391.233933647
X13_13_14_13p n13_13 m13_13_14_13 n5_3 n10_8 prune eta2=0.5 factor=0.0363135139494169 factor2=0.06094987706860226 w0=0
X13_13_14_13m m13_13_14_13 p13_13_14_13 growth w0=0
R13_13_14_13p p13_13_14_13 n14_13 2647391.233933647
X13_13_14_13n q13_13_14_13 m13_13_14_13 growth w0=0
R13_13_14_13n q13_13_14_13 n14_13 2647391.233933647
X13_13_13_14p n13_13 m13_13_13_14 n5_3 n10_8 prune eta2=0.5 factor=0.03572391022599795 factor2=0.06054155685984179 w0=0
X13_13_13_14m m13_13_13_14 p13_13_13_14 growth w0=0
R13_13_13_14p p13_13_13_14 n13_14 2647391.233933647
X13_13_13_14n q13_13_13_14 m13_13_13_14 growth w0=0
R13_13_13_14n q13_13_13_14 n13_14 2647391.233933647
X13_14_14_14p n13_14 m13_14_14_14 n5_3 n10_8 prune eta2=0.5 factor=0.034331725717322424 factor2=0.056209072859076725 w0=0
X13_14_14_14m m13_14_14_14 p13_14_14_14 growth w0=0
R13_14_14_14p p13_14_14_14 n14_14 2647391.233933647
X13_14_14_14n q13_14_14_14 m13_14_14_14 growth w0=0
R13_14_14_14n q13_14_14_14 n14_14 2647391.233933647
X13_14_13_15p n13_14 m13_14_13_15 n5_3 n10_8 prune eta2=0.5 factor=0.03366773854980592 factor2=0.0550313854843489 w0=0
X13_14_13_15m m13_14_13_15 p13_14_13_15 growth w0=0
R13_14_13_15p p13_14_13_15 n13_15 2647391.233933647
X13_14_13_15n q13_14_13_15 m13_14_13_15 growth w0=0
R13_14_13_15n q13_14_13_15 n13_15 2647391.233933647
X13_15_14_15p n13_15 m13_15_14_15 n5_3 n10_8 prune eta2=0.5 factor=0.0325 factor2=0.05177857243343889 w0=0
X13_15_14_15m m13_15_14_15 p13_15_14_15 growth w0=0
R13_15_14_15p p13_15_14_15 n14_15 2647391.233933647
X13_15_14_15n q13_15_14_15 m13_15_14_15 growth w0=0
R13_15_14_15n q13_15_14_15 n14_15 2647391.233933647
X14_1_15_1p n14_1 m14_1_15_1 n5_3 n10_8 prune eta2=0.5 factor=0.04894400901321672 factor2=0.0485524290471993 w0=0
X14_1_15_1m m14_1_15_1 p14_1_15_1 growth w0=0
R14_1_15_1p p14_1_15_1 n15_1 2647391.233933647
X14_1_15_1n q14_1_15_1 m14_1_15_1 growth w0=0
R14_1_15_1n q14_1_15_1 n15_1 2647391.233933647
X14_1_14_2p n14_1 m14_1_14_2 n5_3 n10_8 prune eta2=0.5 factor=0.05518217762500037 factor2=0.056209072859076725 w0=0
X14_1_14_2m m14_1_14_2 p14_1_14_2 growth w0=0
R14_1_14_2p p14_1_14_2 n14_2 2647391.233933647
X14_1_14_2n q14_1_14_2 m14_1_14_2 growth w0=0
R14_1_14_2n q14_1_14_2 n14_2 2647391.233933647
X14_2_15_2p n14_2 m14_2_15_2 n5_3 n10_8 prune eta2=0.5 factor=0.04972951455170391 factor2=0.052100270744641075 w0=0
X14_2_15_2m m14_2_15_2 p14_2_15_2 growth w0=0
R14_2_15_2p p14_2_15_2 n15_2 2647391.233933647
X14_2_15_2n q14_2_15_2 m14_2_15_2 growth w0=0
R14_2_15_2n q14_2_15_2 n15_2 2647391.233933647
X14_2_14_3p n14_2 m14_2_14_3 n5_3 n10_8 prune eta2=0.5 factor=0.05555555555555556 factor2=0.06094987706860226 w0=0
X14_2_14_3m m14_2_14_3 p14_2_14_3 growth w0=0
R14_2_14_3p p14_2_14_3 n14_3 2647391.233933647
X14_2_14_3n q14_2_14_3 m14_2_14_3 growth w0=0
R14_2_14_3n q14_2_14_3 n14_3 2647391.233933647
X14_3_15_3p n14_3 m14_3_15_3 n5_3 n10_8 prune eta2=0.5 factor=0.05 factor2=0.055754704394682934 w0=0
X14_3_15_3m m14_3_15_3 p14_3_15_3 growth w0=0
R14_3_15_3p p14_3_15_3 n15_3 2647391.233933647
X14_3_15_3n q14_3_15_3 m14_3_15_3 growth w0=0
R14_3_15_3n q14_3_15_3 n15_3 2647391.233933647
X14_3_14_4p n14_3 m14_3_14_4 n5_3 n10_8 prune eta2=0.5 factor=0.05518217762500037 factor2=0.0657217333597715 w0=0
X14_3_14_4m m14_3_14_4 p14_3_14_4 growth w0=0
R14_3_14_4p p14_3_14_4 n14_4 2647391.233933647
X14_3_14_4n q14_3_14_4 m14_3_14_4 growth w0=0
R14_3_14_4n q14_3_14_4 n14_4 2647391.233933647
X14_4_15_4p n14_4 m14_4_15_4 n5_3 n10_8 prune eta2=0.5 factor=0.04972951455170391 factor2=0.05930258309377517 w0=0
X14_4_15_4m m14_4_15_4 p14_4_15_4 growth w0=0
R14_4_15_4p p14_4_15_4 n15_4 2647391.233933647
X14_4_15_4n q14_4_15_4 m14_4_15_4 growth w0=0
R14_4_15_4n q14_4_15_4 n15_4 2647391.233933647
X14_4_14_5p n14_4 m14_4_14_5 n5_3 n10_8 prune eta2=0.5 factor=0.054106245026998005 factor2=0.06999999999999999 w0=0
X14_4_14_5m m14_4_14_5 p14_4_14_5 growth w0=0
R14_4_14_5p p14_4_14_5 n14_5 2647391.233933647
X14_4_14_5n q14_4_14_5 m14_4_14_5 growth w0=0
R14_4_14_5n q14_4_14_5 n14_5 2647391.233933647
X14_5_15_5p n14_5 m14_5_15_5 n5_3 n10_8 prune eta2=0.5 factor=0.04894400901321672 factor2=0.0624320877676086 w0=0
X14_5_15_5m m14_5_15_5 p14_5_15_5 growth w0=0
R14_5_15_5p p14_5_15_5 n15_5 2647391.233933647
X14_5_15_5n q14_5_15_5 m14_5_15_5 growth w0=0
R14_5_15_5n q14_5_15_5 n15_5 2647391.233933647
X14_5_14_6p n14_5 m14_5_14_6 n5_3 n10_8 prune eta2=0.5 factor=0.052446720666042994 factor2=0.07309759905262272 w0=0
X14_5_14_6m m14_5_14_6 p14_5_14_6 growth w0=0
R14_5_14_6p p14_5_14_6 n14_6 2647391.233933647
X14_5_14_6n q14_5_14_6 m14_5_14_6 growth w0=0
R14_5_14_6n q14_5_14_6 n14_6 2647391.233933647
X14_6_15_6p n14_6 m14_6_15_6 n5_3 n10_8 prune eta2=0.5 factor=0.04771476701326687 factor2=0.06480539123844095 w0=0
X14_6_15_6m m14_6_15_6 p14_6_15_6 growth w0=0
R14_6_15_6p p14_6_15_6 n15_6 2647391.233933647
X14_6_15_6n q14_6_15_6 m14_6_15_6 growth w0=0
R14_6_15_6n q14_6_15_6 n15_6 2647391.233933647
X14_6_14_7p n14_6 m14_6_14_7 n5_3 n10_8 prune eta2=0.5 factor=0.05036398877740481 factor2=0.07463303884748085 w0=0
X14_6_14_7m m14_6_14_7 p14_6_14_7 growth w0=0
R14_6_14_7p p14_6_14_7 n14_7 2647391.233933647
X14_6_14_7n q14_6_14_7 m14_6_14_7 growth w0=0
R14_6_14_7n q14_6_14_7 n14_7 2647391.233933647
X14_7_15_7p n14_7 m14_7_15_7 n5_3 n10_8 prune eta2=0.5 factor=0.0461417365591415 factor2=0.06621493060419115 w0=0
X14_7_15_7m m14_7_15_7 p14_7_15_7 growth w0=0
R14_7_15_7p p14_7_15_7 n15_7 2647391.233933647
X14_7_15_7n q14_7_15_7 m14_7_15_7 growth w0=0
R14_7_15_7n q14_7_15_7 n15_7 2647391.233933647
X14_7_14_8p n14_7 m14_7_14_8 n5_3 n10_8 prune eta2=0.5 factor=0.04802324646062467 factor2=0.075 w0=0
X14_7_14_8m m14_7_14_8 p14_7_14_8 growth w0=0
R14_7_14_8p p14_7_14_8 n14_8 2647391.233933647
X14_7_14_8n q14_7_14_8 m14_7_14_8 growth w0=0
R14_7_14_8n q14_7_14_8 n14_8 2647391.233933647
X14_8_15_8p n14_8 m14_8_15_8 n5_3 n10_8 prune eta2=0.5 factor=0.044333738219753484 factor2=0.06666666666666667 w0=0
X14_8_15_8m m14_8_15_8 p14_8_15_8 growth w0=0
R14_8_15_8p p14_8_15_8 n15_8 2647391.233933647
X14_8_15_8n q14_8_15_8 m14_8_15_8 growth w0=0
R14_8_15_8n q14_8_15_8 n15_8 2647391.233933647
X14_8_14_9p n14_9 m14_8_14_9 n5_3 n10_8 prune eta2=0.5 factor=0.04802324646062467 factor2=0.075 w0=0
X14_8_14_9m m14_8_14_9 p14_8_14_9 growth w0=0
R14_8_14_9p p14_8_14_9 n14_8 6006.050391399449
X14_8_14_9n q14_8_14_9 m14_8_14_9 growth w0=0
R14_8_14_9n q14_8_14_9 n14_8 3004981.5674761934
X14_9_15_9p n14_9 m14_9_15_9 n5_3 n10_8 prune eta2=0.5 factor=0.04239210112458681 factor2=0.06621493060419115 w0=0
X14_9_15_9m m14_9_15_9 p14_9_15_9 growth w0=0
R14_9_15_9p p14_9_15_9 n15_9 2647391.233933647
X14_9_15_9n q14_9_15_9 m14_9_15_9 growth w0=0
R14_9_15_9n q14_9_15_9 n15_9 2647391.233933647
X14_9_14_10p n14_10 m14_9_14_10 n5_3 n10_8 prune eta2=0.5 factor=0.04556802174054626 factor2=0.07463303884748085 w0=0
X14_9_14_10m m14_9_14_10 p14_9_14_10 growth w0=0
R14_9_14_10p p14_9_14_10 n14_9 6006.050391399449
X14_9_14_10n q14_9_14_10 m14_9_14_10 growth w0=0
R14_9_14_10n q14_9_14_10 n14_9 3004981.5674761934
X14_10_15_10p n14_10 m14_10_15_10 n5_3 n10_8 prune eta2=0.5 factor=0.040400923791530444 factor2=0.06480539123844095 w0=0
X14_10_15_10m m14_10_15_10 p14_10_15_10 growth w0=0
R14_10_15_10p p14_10_15_10 n15_10 2647391.233933647
X14_10_15_10n q14_10_15_10 m14_10_15_10 growth w0=0
R14_10_15_10n q14_10_15_10 n15_10 2647391.233933647
X14_10_14_11p n14_11 m14_10_14_11 n5_3 n10_8 prune eta2=0.5 factor=0.04310804534549201 factor2=0.07309759905262272 w0=0
X14_10_14_11m m14_10_14_11 p14_10_14_11 growth w0=0
R14_10_14_11p p14_10_14_11 n14_10 6006.050391399449
X14_10_14_11n q14_10_14_11 m14_10_14_11 growth w0=0
R14_10_14_11n q14_10_14_11 n14_10 3004981.5674761934
X14_11_15_11p n14_11 m14_11_15_11 n5_3 n10_8 prune eta2=0.5 factor=0.03842374746795286 factor2=0.0624320877676086 w0=0
X14_11_15_11m m14_11_15_11 p14_11_15_11 growth w0=0
R14_11_15_11p p14_11_15_11 n15_11 2647391.233933647
X14_11_15_11n q14_11_15_11 m14_11_15_11 growth w0=0
R14_11_15_11n q14_11_15_11 n15_11 2647391.233933647
X14_11_14_12p n14_12 m14_11_14_12 n5_3 n10_8 prune eta2=0.5 factor=0.040718524069301085 factor2=0.06999999999999999 w0=0
X14_11_14_12m m14_11_14_12 p14_11_14_12 growth w0=0
R14_11_14_12p p14_11_14_12 n14_11 6006.050391399449
X14_11_14_12n q14_11_14_12 m14_11_14_12 growth w0=0
R14_11_14_12n q14_11_14_12 n14_11 3004981.5674761934
X14_12_15_12p n15_12 m14_12_15_12 n5_3 n10_8 prune eta2=0.5 factor=0.03844556921425108 factor2=0.0657217333597715 w0=0
X14_12_15_12m m14_12_15_12 p14_12_15_12 growth w0=0
R14_12_15_12p p14_12_15_12 n14_12 6006.050391399449
X14_12_15_12n q14_12_15_12 m14_12_15_12 growth w0=0
R14_12_15_12n q14_12_15_12 n14_12 3004981.5674761934
X14_12_14_13p n14_12 m14_12_14_13 n5_3 n10_8 prune eta2=0.5 factor=0.0363135139494169 factor2=0.06094987706860226 w0=0
X14_12_14_13m m14_12_14_13 p14_12_14_13 growth w0=0
R14_12_14_13p p14_12_14_13 n14_13 2647391.233933647
X14_12_14_13n q14_12_14_13 m14_12_14_13 growth w0=0
R14_12_14_13n q14_12_14_13 n14_13 2647391.233933647
X14_13_15_13p n14_13 m14_13_15_13 n5_3 n10_8 prune eta2=0.5 factor=0.03467146332893844 factor2=0.055754704394682934 w0=0
X14_13_15_13m m14_13_15_13 p14_13_15_13 growth w0=0
R14_13_15_13p p14_13_15_13 n15_13 2647391.233933647
X14_13_15_13n q14_13_15_13 m14_13_15_13 growth w0=0
R14_13_15_13n q14_13_15_13 n15_13 2647391.233933647
X14_13_14_14p n14_13 m14_13_14_14 n5_3 n10_8 prune eta2=0.5 factor=0.034331725717322424 factor2=0.056209072859076725 w0=0
X14_13_14_14m m14_13_14_14 p14_13_14_14 growth w0=0
R14_13_14_14p p14_13_14_14 n14_14 2647391.233933647
X14_13_14_14n q14_13_14_14 m14_13_14_14 growth w0=0
R14_13_14_14n q14_13_14_14 n14_14 2647391.233933647
X14_14_15_14p n14_14 m14_14_15_14 n5_3 n10_8 prune eta2=0.5 factor=0.032939756073946676 factor2=0.052100270744641075 w0=0
X14_14_15_14m m14_14_15_14 p14_14_15_14 growth w0=0
R14_14_15_14p p14_14_15_14 n15_14 2647391.233933647
X14_14_15_14n q14_14_15_14 m14_14_15_14 growth w0=0
R14_14_15_14n q14_14_15_14 n15_14 2647391.233933647
X14_14_14_15p n14_14 m14_14_14_15 n5_3 n10_8 prune eta2=0.5 factor=0.0325 factor2=0.05177857243343889 w0=0
X14_14_14_15m m14_14_14_15 p14_14_14_15 growth w0=0
R14_14_14_15p p14_14_14_15 n14_15 2647391.233933647
X14_14_14_15n q14_14_14_15 m14_14_14_15 growth w0=0
R14_14_14_15n q14_14_14_15 n14_15 2647391.233933647
X14_15_15_15p n14_15 m14_15_15_15 n5_3 n10_8 prune eta2=0.5 factor=0.03131625544222307 factor2=0.0485524290471993 w0=0
X14_15_15_15m m14_15_15_15 p14_15_15_15 growth w0=0
R14_15_15_15p p14_15_15_15 n15_15 2647391.233933647
X14_15_15_15n q14_15_15_15 m14_15_15_15 growth w0=0
R14_15_15_15n q14_15_15_15 n15_15 2647391.233933647
X15_1_15_2p n15_1 m15_1_15_2 n5_3 n10_8 prune eta2=0.5 factor=0.04972951455170391 factor2=0.052100270744641075 w0=0
X15_1_15_2m m15_1_15_2 p15_1_15_2 growth w0=0
R15_1_15_2p p15_1_15_2 n15_2 2647391.233933647
X15_1_15_2n q15_1_15_2 m15_1_15_2 growth w0=0
R15_1_15_2n q15_1_15_2 n15_2 2647391.233933647
X15_2_15_3p n15_2 m15_2_15_3 n5_3 n10_8 prune eta2=0.5 factor=0.05 factor2=0.055754704394682934 w0=0
X15_2_15_3m m15_2_15_3 p15_2_15_3 growth w0=0
R15_2_15_3p p15_2_15_3 n15_3 2647391.233933647
X15_2_15_3n q15_2_15_3 m15_2_15_3 growth w0=0
R15_2_15_3n q15_2_15_3 n15_3 2647391.233933647
X15_3_15_4p n15_3 m15_3_15_4 n5_3 n10_8 prune eta2=0.5 factor=0.04972951455170391 factor2=0.05930258309377517 w0=0
X15_3_15_4m m15_3_15_4 p15_3_15_4 growth w0=0
R15_3_15_4p p15_3_15_4 n15_4 2647391.233933647
X15_3_15_4n q15_3_15_4 m15_3_15_4 growth w0=0
R15_3_15_4n q15_3_15_4 n15_4 2647391.233933647
X15_4_15_5p n15_4 m15_4_15_5 n5_3 n10_8 prune eta2=0.5 factor=0.04894400901321672 factor2=0.0624320877676086 w0=0
X15_4_15_5m m15_4_15_5 p15_4_15_5 growth w0=0
R15_4_15_5p p15_4_15_5 n15_5 2647391.233933647
X15_4_15_5n q15_4_15_5 m15_4_15_5 growth w0=0
R15_4_15_5n q15_4_15_5 n15_5 2647391.233933647
X15_5_15_6p n15_5 m15_5_15_6 n5_3 n10_8 prune eta2=0.5 factor=0.04771476701326687 factor2=0.06480539123844095 w0=0
X15_5_15_6m m15_5_15_6 p15_5_15_6 growth w0=0
R15_5_15_6p p15_5_15_6 n15_6 2647391.233933647
X15_5_15_6n q15_5_15_6 m15_5_15_6 growth w0=0
R15_5_15_6n q15_5_15_6 n15_6 2647391.233933647
X15_6_15_7p n15_6 m15_6_15_7 n5_3 n10_8 prune eta2=0.5 factor=0.0461417365591415 factor2=0.06621493060419115 w0=0
X15_6_15_7m m15_6_15_7 p15_6_15_7 growth w0=0
R15_6_15_7p p15_6_15_7 n15_7 2647391.233933647
X15_6_15_7n q15_6_15_7 m15_6_15_7 growth w0=0
R15_6_15_7n q15_6_15_7 n15_7 2647391.233933647
X15_7_15_8p n15_7 m15_7_15_8 n5_3 n10_8 prune eta2=0.5 factor=0.044333738219753484 factor2=0.06666666666666667 w0=0
X15_7_15_8m m15_7_15_8 p15_7_15_8 growth w0=0
R15_7_15_8p p15_7_15_8 n15_8 2647391.233933647
X15_7_15_8n q15_7_15_8 m15_7_15_8 growth w0=0
R15_7_15_8n q15_7_15_8 n15_8 2647391.233933647
X15_8_15_9p n15_8 m15_8_15_9 n5_3 n10_8 prune eta2=0.5 factor=0.04239210112458681 factor2=0.06621493060419115 w0=0
X15_8_15_9m m15_8_15_9 p15_8_15_9 growth w0=0
R15_8_15_9p p15_8_15_9 n15_9 2647391.233933647
X15_8_15_9n q15_8_15_9 m15_8_15_9 growth w0=0
R15_8_15_9n q15_8_15_9 n15_9 2647391.233933647
X15_9_15_10p n15_9 m15_9_15_10 n5_3 n10_8 prune eta2=0.5 factor=0.040400923791530444 factor2=0.06480539123844095 w0=0
X15_9_15_10m m15_9_15_10 p15_9_15_10 growth w0=0
R15_9_15_10p p15_9_15_10 n15_10 2647391.233933647
X15_9_15_10n q15_9_15_10 m15_9_15_10 growth w0=0
R15_9_15_10n q15_9_15_10 n15_10 2647391.233933647
X15_10_15_11p n15_10 m15_10_15_11 n5_3 n10_8 prune eta2=0.5 factor=0.03842374746795286 factor2=0.0624320877676086 w0=0
X15_10_15_11m m15_10_15_11 p15_10_15_11 growth w0=0
R15_10_15_11p p15_10_15_11 n15_11 2647391.233933647
X15_10_15_11n q15_10_15_11 m15_10_15_11 growth w0=0
R15_10_15_11n q15_10_15_11 n15_11 2647391.233933647
X15_11_15_12p n15_11 m15_11_15_12 n5_3 n10_8 prune eta2=0.5 factor=0.03650463770704541 factor2=0.05930258309377517 w0=0
X15_11_15_12m m15_11_15_12 p15_11_15_12 growth w0=0
R15_11_15_12p p15_11_15_12 n15_12 2647391.233933647
X15_11_15_12n q15_11_15_12 m15_11_15_12 growth w0=0
R15_11_15_12n q15_11_15_12 n15_12 2647391.233933647
X15_12_15_13p n15_13 m15_12_15_13 n5_3 n10_8 prune eta2=0.5 factor=0.03650463770704541 factor2=0.05930258309377517 w0=0
X15_12_15_13m m15_12_15_13 p15_12_15_13 growth w0=0
R15_12_15_13p p15_12_15_13 n15_12 6006.050391399449
X15_12_15_13n q15_12_15_13 m15_12_15_13 growth w0=0
R15_12_15_13n q15_12_15_13 n15_12 3004981.5674761934
X15_13_15_14p n15_14 m15_13_15_14 n5_3 n10_8 prune eta2=0.5 factor=0.03467146332893844 factor2=0.055754704394682934 w0=0
X15_13_15_14m m15_13_15_14 p15_13_15_14 growth w0=0
R15_13_15_14p p15_13_15_14 n15_13 6006.050391399449
X15_13_15_14n q15_13_15_14 m15_13_15_14 growth w0=0
R15_13_15_14n q15_13_15_14 n15_13 3004981.5674761934
X15_14_15_15p n15_15 m15_14_15_15 n5_3 n10_8 prune eta2=0.5 factor=0.032939756073946676 factor2=0.052100270744641075 w0=0
X15_14_15_15m m15_14_15_15 p15_14_15_15 growth w0=0
R15_14_15_15p p15_14_15_15 n15_14 6006.050391399449
X15_14_15_15n q15_14_15_15 m15_14_15_15 growth w0=0
R15_14_15_15n q15_14_15_15 n15_14 3004981.5674761934
Xs1 n5_4 n5_3 synapse w0=0
Xs2 n6_3 n5_3 synapse w0=0
Xs3 n9_8 n10_8 synapse w0=0
Xs4 n11_8 n10_8 synapse w0=0
.ic v(n1_1)=-0.06938883967919465 v(n1_2)=-0.06938883967919465 v(n1_3)=-0.06938883967919465 v(n1_4)=-0.06938883967919465 v(n1_5)=-0.06938883967919465 v(n1_6)=-0.06938883967919465 v(n1_7)=-0.06938883967919465 v(n1_8)=-0.06938883967919465 v(n1_9)=-0.06938883967919465 v(n1_10)=-0.06938883967919465 v(n1_11)=-0.06938883967919465 v(n1_12)=-0.06938883967919465 v(n1_13)=-0.06938883967919465 v(n1_14)=-0.06938883967919465 v(n1_15)=-0.06938883967919465 v(n2_1)=-0.06938883967919465 v(n2_2)=-0.06938883967919465 v(n2_3)=-0.06938883967919465 v(n2_4)=-0.06938883967919465 v(n2_5)=-0.06938883967919465 v(n2_6)=-0.06938883967919465 v(n2_7)=-0.06938883967919465 v(n2_8)=-0.06938883967919465 v(n2_9)=-0.06938883967919465 v(n2_10)=-0.06938883967919465 v(n2_11)=-0.06938883967919465 v(n2_12)=-0.06938883967919465 v(n2_13)=-0.06938883967919465 v(n2_14)=-0.06938883967919465 v(n2_15)=-0.06938883967919465 v(n3_1)=-0.06938883967919465 v(n3_2)=-0.06938883967919465 v(n3_3)=-0.06938883967919465 v(n3_4)=-0.06938883967919465 v(n3_5)=-0.06938883967919465 v(n3_6)=-0.06938883967919465 v(n3_7)=-0.06938883967919465 v(n3_8)=-0.06938883967919465 v(n3_9)=-0.06938883967919465 v(n3_10)=-0.06938883967919465 v(n3_11)=-0.06938883967919465 v(n3_12)=-0.06938883967919465 v(n3_13)=-0.06938883967919465 v(n3_14)=-0.06938883967919465 v(n3_15)=-0.06938883967919465 v(n4_1)=-0.06938883967919465 v(n4_2)=-0.06938883967919465 v(n4_3)=-0.06938883967919465 v(n4_4)=-0.06938883967919465 v(n4_5)=-0.06938883967919465 v(n4_6)=-0.06938883967919465 v(n4_7)=-0.06938883967919465 v(n4_8)=-0.06938883967919465 v(n4_9)=-0.06938883967919465 v(n4_10)=-0.06938883967919465 v(n4_11)=-0.06938883967919465 v(n4_12)=-0.06938883967919465 v(n4_13)=-0.06938883967919465 v(n4_14)=-0.06938883967919465 v(n4_15)=-0.06938883967919465 v(n5_1)=-0.06938883967919465 v(n5_2)=-0.06938883967919465 v(n5_3)=-0.06938883967919465 v(n5_4)=-0.06938883967919465 v(n5_5)=-0.06938883967919465 v(n5_6)=-0.06938883967919465 v(n5_7)=-0.06938883967919465 v(n5_8)=-0.06938883967919465 v(n5_9)=-0.06938883967919465 v(n5_10)=-0.06938883967919465 v(n5_11)=-0.06938883967919465 v(n5_12)=-0.06938883967919465 v(n5_13)=-0.06938883967919465 v(n5_14)=-0.06938883967919465 v(n5_15)=-0.06938883967919465 v(n6_1)=-0.06938883967919465 v(n6_2)=-0.06938883967919465 v(n6_3)=-0.06938883967919465 v(n6_4)=-0.06938883967919465 v(n6_5)=-0.06938883967919465 v(n6_6)=-0.06938883967919465 v(n6_7)=-0.06938883967919465 v(n6_8)=-0.06938883967919465 v(n6_9)=-0.06938883967919465 v(n6_10)=-0.06938883967919465 v(n6_11)=-0.06938883967919465 v(n6_12)=-0.06938883967919465 v(n6_13)=-0.06938883967919465 v(n6_14)=-0.06938883967919465 v(n6_15)=-0.06938883967919465 v(n7_1)=-0.06938883967919465 v(n7_2)=-0.06938883967919465 v(n7_3)=-0.06938883967919465 v(n7_4)=-0.06938883967919465 v(n7_5)=-0.06938883967919465 v(n7_6)=-0.06938883967919465 v(n7_7)=-0.06938883967919465 v(n7_8)=-0.06938883967919465 v(n7_9)=-0.06938883967919465 v(n7_10)=-0.06938883967919465 v(n7_11)=-0.06938883967919465 v(n7_12)=-0.06938883967919465 v(n7_13)=-0.06938883967919465 v(n7_14)=-0.06938883967919465 v(n7_15)=-0.06938883967919465 v(n8_1)=-0.06938883967919465 v(n8_2)=-0.06938883967919465 v(n8_3)=-0.06938883967919465 v(n8_4)=-0.06938883967919465 v(n8_5)=-0.06938883967919465 v(n8_6)=-0.06938883967919465 v(n8_7)=-0.06938883967919465 v(n8_8)=-0.06938883967919465 v(n8_9)=-0.06938883967919465 v(n8_10)=-0.06938883967919465 v(n8_11)=-0.06938883967919465 v(n8_12)=-0.06938883967919465 v(n8_13)=-0.06938883967919465 v(n8_14)=-0.06938883967919465 v(n8_15)=-0.06938883967919465 v(n9_1)=-0.06938883967919465 v(n9_2)=-0.06938883967919465 v(n9_3)=-0.06938883967919465 v(n9_4)=-0.06938883967919465 v(n9_5)=-0.06938883967919465 v(n9_6)=-0.06938883967919465 v(n9_7)=-0.06938883967919465 v(n9_8)=-0.06938883967919465 v(n9_9)=-0.06938883967919465 v(n9_10)=-0.06938883967919465 v(n9_11)=-0.06938883967919465 v(n9_12)=-0.06938883967919465 v(n9_13)=-0.06938883967919465 v(n9_14)=-0.06938883967919465 v(n9_15)=-0.06938883967919465 v(n10_1)=-0.06938883967919465 v(n10_2)=-0.06938883967919465 v(n10_3)=-0.06938883967919465 v(n10_4)=-0.06938883967919465 v(n10_5)=-0.06938883967919465 v(n10_6)=-0.06938883967919465 v(n10_7)=-0.06938883967919465 v(n10_8)=-0.06938883967919465 v(n10_9)=-0.06938883967919465 v(n10_10)=-0.06938883967919465 v(n10_11)=-0.06938883967919465 v(n10_12)=-0.06938883967919465 v(n10_13)=-0.06938883967919465 v(n10_14)=-0.06938883967919465 v(n10_15)=-0.06938883967919465 v(n11_1)=-0.06938883967919465 v(n11_2)=-0.06938883967919465 v(n11_3)=-0.06938883967919465 v(n11_4)=-0.06938883967919465 v(n11_5)=-0.06938883967919465 v(n11_6)=-0.06938883967919465 v(n11_7)=-0.06938883967919465 v(n11_8)=-0.06938883967919465 v(n11_9)=-0.06938883967919465 v(n11_10)=-0.06938883967919465 v(n11_11)=-0.06938883967919465 v(n11_12)=-0.06938883967919465 v(n11_13)=-0.06938883967919465 v(n11_14)=-0.06938883967919465 v(n11_15)=-0.06938883967919465 v(n12_1)=-0.06938883967919465 v(n12_2)=-0.06938883967919465 v(n12_3)=-0.06938883967919465 v(n12_4)=-0.06938883967919465 v(n12_5)=-0.06938883967919465 v(n12_6)=-0.06938883967919465 v(n12_7)=-0.06938883967919465 v(n12_8)=-0.06938883967919465 v(n12_9)=-0.06938883967919465 v(n12_10)=-0.06938883967919465 v(n12_11)=-0.06938883967919465 v(n12_12)=-0.06938883967919465 v(n12_13)=-0.06938883967919465 v(n12_14)=-0.06938883967919465 v(n12_15)=-0.06938883967919465 v(n13_1)=-0.06938883967919465 v(n13_2)=-0.06938883967919465 v(n13_3)=-0.06938883967919465 v(n13_4)=-0.06938883967919465 v(n13_5)=-0.06938883967919465 v(n13_6)=-0.06938883967919465 v(n13_7)=-0.06938883967919465 v(n13_8)=-0.06938883967919465 v(n13_9)=-0.06938883967919465 v(n13_10)=-0.06938883967919465 v(n13_11)=-0.06938883967919465 v(n13_12)=-0.06938883967919465 v(n13_13)=-0.06938883967919465 v(n13_14)=-0.06938883967919465 v(n13_15)=-0.06938883967919465 v(n14_1)=-0.06938883967919465 v(n14_2)=-0.06938883967919465 v(n14_3)=-0.06938883967919465 v(n14_4)=-0.06938883967919465 v(n14_5)=-0.06938883967919465 v(n14_6)=-0.06938883967919465 v(n14_7)=-0.06938883967919465 v(n14_8)=-0.06938883967919465 v(n14_9)=-0.06938883967919465 v(n14_10)=-0.06938883967919465 v(n14_11)=-0.06938883967919465 v(n14_12)=-0.06938883967919465 v(n14_13)=-0.06938883967919465 v(n14_14)=-0.06938883967919465 v(n14_15)=-0.06938883967919465 v(n15_1)=-0.06938883967919465 v(n15_2)=-0.06938883967919465 v(n15_3)=-0.06938883967919465 v(n15_4)=-0.06938883967919465 v(n15_5)=-0.06938883967919465 v(n15_6)=-0.06938883967919465 v(n15_7)=-0.06938883967919465 v(n15_8)=-0.06938883967919465 v(n15_9)=-0.06938883967919465 v(n15_10)=-0.06938883967919465 v(n15_11)=-0.06938883967919465 v(n15_12)=-0.06938883967919465 v(n15_13)=-0.06938883967919465 v(n15_14)=-0.06938883967919465 v(n15_15)=-0.06938883967919465
.options vntol=1e-9
.tran 0.1m 5
.print tran v(n3_15) v(n15_15) v(n5_3) v(n10_8) v(n3_14) v(n4_14) v(n4_13) v(n5_13) v(n5_5) v(n5_4) v(n5_6) v(n5_7) v(n5_8) v(n6_8) v(n5_9) v(n5_10) v(n5_11) v(n5_12) v(n7_3) v(n6_3) v(n7_8) v(n7_4) v(n7_5) v(n8_5) v(n8_8) v(n8_6) v(n9_6) v(n9_8) v(n10_6) v(n11_6) v(n11_7) v(n11_8) v(n12_8) v(n13_8) v(n14_8) v(n14_9) v(n14_10) v(n14_11) v(n14_12) v(n15_12) v(n15_13) v(n15_14) v(m3_14_4_14) v(p3_14_4_14) i(R3_14_4_14p) i(R3_14_4_14n) v(m3_14_3_15) v(p3_14_3_15) i(R3_14_3_15p) i(R3_14_3_15n) v(m4_13_5_13) v(p4_13_5_13) i(R4_13_5_13p) i(R4_13_5_13n) v(m4_13_4_14) v(p4_13_4_14) i(R4_13_4_14p) i(R4_13_4_14n) v(m5_4_5_5) v(p5_4_5_5) i(R5_4_5_5p) i(R5_4_5_5n) v(m5_5_5_6) v(p5_5_5_6) i(R5_5_5_6p) i(R5_5_5_6n) v(m5_6_5_7) v(p5_6_5_7) i(R5_6_5_7p) i(R5_6_5_7n) v(m5_7_5_8) v(p5_7_5_8) i(R5_7_5_8p) i(R5_7_5_8n) v(m5_8_6_8) v(p5_8_6_8) i(R5_8_6_8p) i(R5_8_6_8n) v(m5_8_5_9) v(p5_8_5_9) i(R5_8_5_9p) i(R5_8_5_9n) v(m5_9_5_10) v(p5_9_5_10) i(R5_9_5_10p) i(R5_9_5_10n) v(m5_10_5_11) v(p5_10_5_11) i(R5_10_5_11p) i(R5_10_5_11n) v(m5_11_5_12) v(p5_11_5_12) i(R5_11_5_12p) i(R5_11_5_12n) v(m5_12_5_13) v(p5_12_5_13) i(R5_12_5_13p) i(R5_12_5_13n) v(m6_3_7_3) v(p6_3_7_3) i(R6_3_7_3p) i(R6_3_7_3n) v(m6_8_7_8) v(p6_8_7_8) i(R6_8_7_8p) i(R6_8_7_8n) v(m7_3_7_4) v(p7_3_7_4) i(R7_3_7_4p) i(R7_3_7_4n) v(m7_4_7_5) v(p7_4_7_5) i(R7_4_7_5p) i(R7_4_7_5n) v(m7_5_8_5) v(p7_5_8_5) i(R7_5_8_5p) i(R7_5_8_5n) v(m7_8_8_8) v(p7_8_8_8) i(R7_8_8_8p) i(R7_8_8_8n) v(m8_5_8_6) v(p8_5_8_6) i(R8_5_8_6p) i(R8_5_8_6n) v(m8_6_9_6) v(p8_6_9_6) i(R8_6_9_6p) i(R8_6_9_6n) v(m8_8_9_8) v(p8_8_9_8) i(R8_8_9_8p) i(R8_8_9_8n) v(m9_6_10_6) v(p9_6_10_6) i(R9_6_10_6p) i(R9_6_10_6n) v(m10_6_11_6) v(p10_6_11_6) i(R10_6_11_6p) i(R10_6_11_6n) v(m11_6_11_7) v(p11_6_11_7) i(R11_6_11_7p) i(R11_6_11_7n) v(m11_7_11_8) v(p11_7_11_8) i(R11_7_11_8p) i(R11_7_11_8n) v(m11_8_12_8) v(p11_8_12_8) i(R11_8_12_8p) i(R11_8_12_8n) v(m12_8_13_8) v(p12_8_13_8) i(R12_8_13_8p) i(R12_8_13_8n) v(m13_8_14_8) v(p13_8_14_8) i(R13_8_14_8p) i(R13_8_14_8n) v(m14_8_14_9) v(p14_8_14_9) i(R14_8_14_9p) i(R14_8_14_9n) v(m14_9_14_10) v(p14_9_14_10) i(R14_9_14_10p) i(R14_9_14_10n) v(m14_10_14_11) v(p14_10_14_11) i(R14_10_14_11p) i(R14_10_14_11n) v(m14_11_14_12) v(p14_11_14_12) i(R14_11_14_12p) i(R14_11_14_12n) v(m14_12_15_12) v(p14_12_15_12) i(R14_12_15_12p) i(R14_12_15_12n) v(m15_12_15_13) v(p15_12_15_13) i(R15_12_15_13p) i(R15_12_15_13n) v(m15_13_15_14) v(p15_13_15_14) i(R15_13_15_14p) i(R15_13_15_14n) v(m15_14_15_15) v(p15_14_15_15) i(R15_14_15_15p) i(R15_14_15_15n)
.end

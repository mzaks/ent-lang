A resistive divider: 10 V over 1k and 2k, a third of it across the 1k
V1 in 0 DC 10
R1 in out 2k
R2 out 0 1k
.op
.print v(out) i(V1)
.end
